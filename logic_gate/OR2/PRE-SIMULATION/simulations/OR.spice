** sch_path: /home/tundzi-lp1710/LAYOUT_ANALOG_FALL_DTVT/Bai_Tap_Buoi_2/OR_GATE/OR.sch
**.subckt OR A B Y VDD VSS
*.ipin A
*.ipin B
*.opin Y
*.iopin VDD
*.iopin VSS
XM1 net2 A VSS VSS sg13_lv_nmos w=0.15u l=0.13u ng=1
XM2 net1 A VDD VDD sg13_lv_pmos w=0.15u l=0.13u ng=1
XM3 net2 B net1 VDD sg13_lv_pmos w=0.15u l=0.13u ng=1
XM4 net2 B VSS VSS sg13_lv_nmos w=0.15u l=0.13u ng=1
XM5 Y net2 VDD VDD sg13_lv_pmos w=0.15u l=0.13u ng=1
XM6 Y net2 VSS VSS sg13_lv_nmos w=0.15u l=0.13u ng=1
**.ends
.end
