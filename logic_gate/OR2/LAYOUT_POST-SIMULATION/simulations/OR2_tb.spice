** sch_path: /home/tundzi-lp1710/LAYOUT_ANALOG_FALL_DTVT/Bai_Tap_Buoi_2/OR_GATE/Layout/OR2_tb.sch
**.subckt OR2_tb
VDD Vdd Vss 2.1
VSS Vss 0 0
VA Va Vss PULSE(0 2.1 0 50p 50p 10n 20n)
VB Vb Vss PULSE(0 2.1 0 50p 50p 20n 40n)
x1 Vdd Va Vb Vout Vss OR2
**** begin user architecture code

.tran 10p 100n
.save all

.lib cornerMOSlv.lib mos_tt

.inc /home/tundzi-lp1710/LAYOUT_ANALOG_FALL_DTVT/Bai_Tap_Buoi_2/OR_GATE/Layout/OR2.spice

**** end user architecture code
**.ends
.end
