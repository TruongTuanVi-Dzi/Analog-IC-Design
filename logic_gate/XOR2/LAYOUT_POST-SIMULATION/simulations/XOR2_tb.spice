** sch_path: /home/tundzi-lp1710/LAYOUT_ANALOG_FALL_DTVT/Bai_Tap_Buoi_2/XOR_GATE/Layout/XOR2_tb.sch
**.subckt XOR2_tb
VDD Vdd Vss 1.77
VSS Vss 0 0
VA Va Vss PULSE(0 1.77 0 50p 50p 50n 100n)
VB Vb Vss PULSE(0 1.77 0 50p 50p 25n 50n)
x1 Vdd Va Vb Vss Vout XOR2
**** begin user architecture code

.lib cornerMOSlv.lib mos_tt

.tran 10p 300n
.save all

.inc /home/tundzi-lp1710/LAYOUT_ANALOG_FALL_DTVT/Bai_Tap_Buoi_2/XOR_GATE/Layout/XOR2.spice

**** end user architecture code
**.ends
.end
