** sch_path: /home/tundzi-lp1710/LAYOUT_ANALOG_FALL_DTVT/Bai_Tap_Buoi_2/NAND_GATE/NAND_test.sch
**.subckt NAND_test
VA Va Vss PULSE(0 1.2 0 100p 100p 10n 20n)
VB Vb Vss PULSE(0 1.2 0 100p 100p 20n 40n)
VDD Vdd Vss 1.2
VSS Vss 0 0
x1 Vdd Va Vb Vout Vss NAND
**** begin user architecture code

.lib cornerMOSlv.lib mos_tt

.tran 10p 100n
.save all

**** end user architecture code
**.ends

* expanding   symbol:  /home/tundzi-lp1710/LAYOUT_ANALOG_FALL_DTVT/Bai_Tap_Buoi_2/NAND_GATE/NAND.sym # of pins=5
** sym_path: /home/tundzi-lp1710/LAYOUT_ANALOG_FALL_DTVT/Bai_Tap_Buoi_2/NAND_GATE/NAND.sym
** sch_path: /home/tundzi-lp1710/LAYOUT_ANALOG_FALL_DTVT/Bai_Tap_Buoi_2/NAND_GATE/NAND.sch
.subckt NAND VDD A B Y VSS
*.iopin VDD
*.iopin VSS
*.ipin A
*.opin Y
*.ipin B
XM1 Y A net1 VSS sg13_lv_nmos w=0.15u l=0.13u ng=1
XM2 Y A VDD VDD sg13_lv_pmos w=0.15u l=0.13u ng=1
XM4 Y B VDD VDD sg13_lv_pmos w=0.15u l=0.13u ng=1
XM5 net1 B VSS VSS sg13_lv_nmos w=0.15u l=0.13u ng=1
.ends

.end
