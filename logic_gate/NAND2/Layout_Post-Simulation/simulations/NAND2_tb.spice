** sch_path: /home/tundzi-lp1710/LAYOUT_ANALOG_FALL_DTVT/Bai_Tap_Buoi_2/NAND_GATE/Layout/NAND2_tb.sch
**.subckt NAND2_tb
VA Va Vss PULSE(0 1.2 0 100p 100p 10n 20n)
VB Vb Vss PULSE(0 1.2 0 100p 100p 20n 40n)
VDD Vdd Vss 1.2
VSS Vss 0 0
x1 Vb Va Vout Vdd Vss NAND2
**** begin user architecture code

.lib cornerMOSlv.lib mos_tt

.tran 10p 100n
.save all

.inc /home/tundzi-lp1710/LAYOUT_ANALOG_FALL_DTVT/Bai_Tap_Buoi_2/NAND_GATE/Layout/NAND2.spice

**** end user architecture code
**.ends
.end
