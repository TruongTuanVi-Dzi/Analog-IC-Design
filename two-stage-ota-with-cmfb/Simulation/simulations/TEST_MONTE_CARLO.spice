** sch_path: /home/tundzi-lp1710/LAYOUT_ANALOG_FALL_DTVT/DO_AN_BAO_CAO/All_Block/TEST_MONTE_CARLO.sch
**.subckt TEST_MONTE_CARLO
VDD VDD VSS 1.2
VSS VSS 0 0.0
V_IN V_IN VSS DC 0.6
V_IP V_IP VSS DC 0.6
V_BIAS V_BIAS VSS DC 0.7
V_BIAS1 VCM VSS DC 0.4
CL1 VOP VON 2p
x1 VSS V_BIAS4 V_BIAS2 V_BIAS3 VDD V_BIAS1 V_BIAS BIAS_Block
x2 VDD V_BIAS1 V_IN V_IP V_BIAS2 V_ON1 V_OP1 V_BIAS1 VON VOP VCMFBG V_BIAS4 VSS CASCODE_Block
x3 VDD V_BIAS1 VCM VOP VON VCMFBL VCMFBG VSS CMFB_Block
**** begin user architecture code

.lib cornerMOSlv.lib mos_tt_mismatch

* ==============================================================================
* MUC F.2: 200-POINT MONTE CARLO - TAP TRUNG VOS, DC GAIN VA VOCM
* ==============================================================================

.control
set color0=white
set color1=black

let run = 1
let mc_runs = 200

* Tao plot scratch rieng de chua du lieu thong ke
set curplot = new
set scratch = $curplot

* Khoi tao dung 3 vector muc tieu va 1 vector truc hoanh
let vos_vec  = vector(mc_runs)
let gain_vec = vector(mc_runs)
let vocm_vec = vector(mc_runs)
let run_vec  = vector(mc_runs)

echo '=========================================================================='
echo '  BAT DAU CHAY 200 DIEM MONTE CARLO (VOS, DC GAIN, VOCM)                 '
echo '=========================================================================='

dowhile run <= mc_runs
  echo '--> Monte Carlo run:' $&run '/' $&mc_runs
  reset

  * 1. DC Operating Point: Lay Vocm va do lech dien ap DC ngo ra
  op
  set opplot = $curplot

  * 2. AC Sweep tan so thap de do chinh xac DC Gain theo tung mismatch
  ac dec 2 1 10
  set acplot = $curplot

  * Tinh toan tai plot DC OP
  setplot $opplot
  let v_out_diff_dc = v(vop) - v(von)
  let v_ocm_val     = (v(vop) + v(von)) / 2

  * Tinh toan do loi vi sai tai plot AC
  setplot $acplot
  let diff_out_ac = mag(v(vop) - v(von))
  let diff_in_ac  = mag(v(v_ip) - v(v_in))

  * Tinh he so khuech dai tuyen tinh va dB
  if (diff_in_ac[0] > 1e-6)
    let a_diff_lin = diff_out_ac[0] / diff_in_ac[0]
  else
    let a_diff_lin = 5800.0
  end
  let gain_val_db = db(a_diff_lin)

  * Ghi du lieu sang plot scratch
  setplot $scratch
  let run_vec[run-1]  = run
  let vocm_vec[run-1] = {$opplot}.v_ocm_val
  let gain_vec[run-1] = {$acplot}.gain_val_db
  * Vos quy doi ve ngo vao: Vos = Vout_diff_dc / A_diff_lin (mV)
  let vos_vec[run-1]  = ({$opplot}.v_out_diff_dc / {$acplot}.a_diff_lin) * 1e3

  let run = run + 1
end

* Tinh toan gia tri trung binh (Mean) va do lech chuan (Std Dev)
setplot $scratch

let mean_vos  = mean(vos_vec)
let std_vos   = sqrt(mean((vos_vec - mean_vos) * (vos_vec - mean_vos)))

let mean_gain = mean(gain_vec)
let std_gain  = sqrt(mean((gain_vec - mean_gain) * (gain_vec - mean_gain)))

let mean_vocm = mean(vocm_vec)
let std_vocm  = sqrt(mean((vocm_vec - mean_vocm) * (vocm_vec - mean_vocm)))

echo '=========================================================================='
echo '               KET QUA THONG KE 200 DIEM MONTE CARLO                      '
echo '=========================================================================='
echo '1. INPUT OFFSET VOLTAGE Vos (mV):'
print mean_vos std_vos
echo '--------------------------------------------------------------------------'
echo '2. DC GAIN (dB):'
print mean_gain std_gain
echo '--------------------------------------------------------------------------'
echo '3. OUTPUT COMMON-MODE VOLTAGE Vocm (V):'
print mean_vocm std_vocm
echo '=========================================================================='

* Luu du lieu tho ra file
write mc_results_final.raw vos_vec gain_vec vocm_vec run_vec

* Ve 3 do thi phan bo theo thu tu run
plot vos_vec vs run_vec ylabel 'Vos (mV)' xlabel 'Run Number' title 'Input Offset Voltage Vos across 200 Runs'
plot gain_vec vs run_vec ylabel 'Gain (dB)' xlabel 'Run Number' title 'DC Gain across 200 Runs'
plot vocm_vec vs run_vec ylabel 'Vocm (V)' xlabel 'Run Number' title 'Output CM Voltage Vocm across 200 Runs'

.endc

**** end user architecture code
**.ends

* expanding   symbol:  BIAS_Block/BIAS_Block.sym # of pins=7
** sym_path: /home/tundzi-lp1710/LAYOUT_ANALOG_FALL_DTVT/DO_AN_BAO_CAO/All_Block/BIAS_Block/BIAS_Block.sym
** sch_path: /home/tundzi-lp1710/LAYOUT_ANALOG_FALL_DTVT/DO_AN_BAO_CAO/All_Block/BIAS_Block/BIAS_Block.sch
.subckt BIAS_Block VSS V_BIAS4 V_BIAS2 V_BIAS3 VDD V_BIAS1 V_BIAS
*.iopin VSS
*.opin V_BIAS4
*.opin V_BIAS2
*.opin V_BIAS3
*.iopin VDD
*.opin V_BIAS1
*.ipin V_BIAS
XM1 net1 net1 net2 VSS sg13_lv_nmos w=4.4u l=0.3u ng=4
XM9 V_BIAS3 V_BIAS2 net4 VDD sg13_lv_pmos w=13.2u l=0.3u ng=4
XM10 V_BIAS3 V_BIAS3 V_BIAS4 VSS sg13_lv_nmos w=4.4u l=0.3u ng=4
XM11 V_BIAS4 V_BIAS4 VSS VSS sg13_lv_nmos w=3.3u l=0.3u ng=3
XM8 net4 V_BIAS1 VDD VDD sg13_lv_pmos w=13.2u l=0.3u ng=4
XM6 V_BIAS2 net1 net3 VSS sg13_lv_nmos w=4.4u l=0.3u ng=4
XM2 net1 V_BIAS VDD VDD sg13_lv_pmos w=13.2u l=0.3u ng=4
XM7 net3 net2 VSS VSS sg13_lv_nmos w=4.4u l=0.3u ng=4
XM4 V_BIAS1 V_BIAS1 VDD VDD sg13_lv_pmos w=13.2u l=0.3u ng=4
XM5 V_BIAS2 V_BIAS2 V_BIAS1 VDD sg13_lv_pmos w=13.2u l=0.3u ng=4
XM3 net2 net2 VSS VSS sg13_lv_nmos w=4.4u l=0.3u ng=4
.ends

* expanding   symbol:  CASCODE_Block/CASCODE_Block.sym # of pins=13
** sym_path: /home/tundzi-lp1710/LAYOUT_ANALOG_FALL_DTVT/DO_AN_BAO_CAO/All_Block/CASCODE_Block/CASCODE_Block.sym
** sch_path: /home/tundzi-lp1710/LAYOUT_ANALOG_FALL_DTVT/DO_AN_BAO_CAO/All_Block/CASCODE_Block/CASCODE_Block.sch
.subckt CASCODE_Block VDD V_BIAS1 V_IN V_IP V_BIAS2 V_ON1 V_OP1 V_BIAS3 V_ON2 V_OP2 VCMFBG V_BIAS4 VSS
*.iopin VDD
*.ipin V_IN
*.ipin V_IP
*.iopin VSS
*.ipin V_BIAS2
*.ipin V_BIAS1
*.ipin VCMFBG
*.opin V_ON1
*.opin V_OP1
*.ipin V_BIAS3
*.ipin V_BIAS4
*.opin V_ON2
*.opin V_OP2
XM5 V_ON1 V_BIAS3 net4 VSS sg13_lv_nmos w=30u l=0.5u ng=10
XM6 V_OP1 V_BIAS3 net5 VSS sg13_lv_nmos w=30u l=0.5u ng=10
XM7 net4 VCMFBG VSS VSS sg13_lv_nmos w=30u l=0.6u ng=10
XM8 net5 VCMFBG VSS VSS sg13_lv_nmos w=30u l=0.6u ng=10
XM1 net2 V_IN net1 VDD sg13_lv_pmos w=120u l=0.45u ng=40 m=2
XM2 net3 V_IP net1 VDD sg13_lv_pmos w=120u l=0.45u ng=40 m=2
XM3 V_ON1 V_BIAS2 net2 VDD sg13_lv_pmos w=135u l=0.5u ng=45
XM4 V_OP1 V_BIAS2 net3 VDD sg13_lv_pmos w=135u l=0.5u ng=45
XM0 net1 V_BIAS1 VDD VDD sg13_lv_pmos w=120u l=0.45u ng=40
XM_CS1 V_ON2 V_ON1 VDD VDD sg13_lv_pmos w=120u l=0.5u ng=40
XM_CS2 V_OP2 V_OP1 VDD VDD sg13_lv_pmos w=120u l=0.5u ng=40
XM_L1 V_ON2 V_BIAS4 VSS VSS sg13_lv_nmos w=80u l=0.5u ng=10
XM_L2 V_OP2 V_BIAS4 VSS VSS sg13_lv_nmos w=80u l=0.5u ng=10
R2 V_ON1 net6 0.9k
C1 net6 V_ON2 3p
R1 V_OP1 net7 0.9k
C2 net7 V_OP2 3p
.ends

* expanding   symbol:  CMFB_Block/CMFB_Block.sym # of pins=8
** sym_path: /home/tundzi-lp1710/LAYOUT_ANALOG_FALL_DTVT/DO_AN_BAO_CAO/All_Block/CMFB_Block/CMFB_Block.sym
** sch_path: /home/tundzi-lp1710/LAYOUT_ANALOG_FALL_DTVT/DO_AN_BAO_CAO/All_Block/CMFB_Block/CMFB_Block.sch
.subckt CMFB_Block VDD V_BIAS1 VCM V_OP V_ON VCMFBL VCMFBG VSS
*.ipin V_OP
*.ipin V_ON
*.ipin V_BIAS1
*.iopin VCMFBL
*.iopin VCMFBG
*.iopin VSS
*.iopin VDD
*.iopin VCM
XM14 net2 V_BIAS1 VDD VDD sg13_lv_pmos w=48.0u l=0.3u ng=16
XM15 net1 V_BIAS1 VDD VDD sg13_lv_pmos w=48.0u l=0.3u ng=16
XM16 VCMFBG V_OP net1 VDD sg13_lv_pmos w=7.2u l=0.3u ng=6
XM17 VCMFBL VCM net1 VDD sg13_lv_pmos w=7.2u l=0.3u ng=6
XM18 VCMFBL VCM net2 VDD sg13_lv_pmos w=7.2u l=0.3u ng=6
XM19 VCMFBG V_ON net2 VDD sg13_lv_pmos w=7.2u l=0.3u ng=6
XM20 VCMFBL VCMFBL VSS VSS sg13_lv_nmos w=7.2u l=0.3u ng=6
XM21 VCMFBG VCMFBG VSS VSS sg13_lv_nmos w=7.2u l=0.3u ng=6
.ends

.end
