** sch_path: /home/tundzi-lp1710/LAYOUT_ANALOG_FALL_DTVT/DO_AN_BAO_CAO/All_Block/TEST_DC_OP.sch
**.subckt TEST_DC_OP
VDD VDD VSS 1.2
VSS VSS 0 0.0
V_IN V_IN VSS DC 0.6 AC -1.0
V_IP V_IP VSS DC 0.6 AC 1.0
V_BIAS V_BIAS VSS DC 0.7
V_BIAS1 VCM VSS DC 0.4
CL1 VOP VON 2p
x1 VSS V_BIAS4 V_BIAS2 V_BIAS3 VDD V_BIAS1 V_BIAS BIAS_Block
x2 VDD V_BIAS1 V_IN V_IP V_BIAS2 V_ON1 V_OP1 V_BIAS1 VON VOP VCMFBG V_BIAS4 VSS CASCODE_Block
x3 VDD V_BIAS1 VCM VOP VON VCMFBL VCMFBG VSS CMFB_Block
**** begin user architecture code

.lib cornerMOSlv.lib mos_tt

.control
op

echo '=========================================================================='
echo '          A1. CHECK SATURATION & DC PARAMETERS'
echo '=========================================================================='

echo '--- 1. MAIN CASCODE & CS STAGE (x2) ---'
echo '--------------------------------------------------------------------------'
print @n.x2.xm0.nsg13_lv_pmos[vds]     @n.x2.xm0.nsg13_lv_pmos[vgs]     @n.x2.xm0.nsg13_lv_pmos[vth]     @n.x2.xm0.nsg13_lv_pmos[ids]
echo '--------------------------------------------------------------------------'
print @n.x2.xm1.nsg13_lv_pmos[vds]     @n.x2.xm1.nsg13_lv_pmos[vgs]     @n.x2.xm1.nsg13_lv_pmos[vth]     @n.x2.xm1.nsg13_lv_pmos[ids]
echo '--------------------------------------------------------------------------'
print @n.x2.xm2.nsg13_lv_pmos[vds]     @n.x2.xm2.nsg13_lv_pmos[vgs]     @n.x2.xm2.nsg13_lv_pmos[vth]     @n.x2.xm2.nsg13_lv_pmos[ids]
echo '--------------------------------------------------------------------------'
print @n.x2.xm3.nsg13_lv_pmos[vds]     @n.x2.xm3.nsg13_lv_pmos[vgs]     @n.x2.xm3.nsg13_lv_pmos[vth]     @n.x2.xm3.nsg13_lv_pmos[ids]
echo '--------------------------------------------------------------------------'
print @n.x2.xm4.nsg13_lv_pmos[vds]     @n.x2.xm4.nsg13_lv_pmos[vgs]     @n.x2.xm4.nsg13_lv_pmos[vth]     @n.x2.xm4.nsg13_lv_pmos[ids]
echo '--------------------------------------------------------------------------'
print @n.x2.xm5.nsg13_lv_nmos[vds]     @n.x2.xm5.nsg13_lv_nmos[vgs]     @n.x2.xm5.nsg13_lv_nmos[vth]     @n.x2.xm5.nsg13_lv_nmos[ids]
echo '--------------------------------------------------------------------------'
print @n.x2.xm6.nsg13_lv_nmos[vds]     @n.x2.xm6.nsg13_lv_nmos[vgs]     @n.x2.xm6.nsg13_lv_nmos[vth]     @n.x2.xm6.nsg13_lv_nmos[ids]
echo '--------------------------------------------------------------------------'
print @n.x2.xm7.nsg13_lv_nmos[vds]     @n.x2.xm7.nsg13_lv_nmos[vgs]     @n.x2.xm7.nsg13_lv_nmos[vth]     @n.x2.xm7.nsg13_lv_nmos[ids]
echo '--------------------------------------------------------------------------'
print @n.x2.xm8.nsg13_lv_nmos[vds]     @n.x2.xm8.nsg13_lv_nmos[vgs]     @n.x2.xm8.nsg13_lv_nmos[vth]     @n.x2.xm8.nsg13_lv_nmos[ids]
echo '--------------------------------------------------------------------------'
print @n.x2.xm_cs1.nsg13_lv_pmos[vds]  @n.x2.xm_cs1.nsg13_lv_pmos[vgs]  @n.x2.xm_cs1.nsg13_lv_pmos[vth]  @n.x2.xm_cs1.nsg13_lv_pmos[ids]
echo '--------------------------------------------------------------------------'
print @n.x2.xm_cs2.nsg13_lv_pmos[vds]  @n.x2.xm_cs2.nsg13_lv_pmos[vgs]  @n.x2.xm_cs2.nsg13_lv_pmos[vth]  @n.x2.xm_cs2.nsg13_lv_pmos[ids]
echo '--------------------------------------------------------------------------'
print @n.x2.xm_l1.nsg13_lv_nmos[vds]   @n.x2.xm_l1.nsg13_lv_nmos[vgs]   @n.x2.xm_l1.nsg13_lv_nmos[vth]   @n.x2.xm_l1.nsg13_lv_nmos[ids]
echo '--------------------------------------------------------------------------'
print @n.x2.xm_l2.nsg13_lv_nmos[vds]   @n.x2.xm_l2.nsg13_lv_nmos[vgs]   @n.x2.xm_l2.nsg13_lv_nmos[vth]   @n.x2.xm_l2.nsg13_lv_nmos[ids]

echo '=========================================================================='
echo '--- 2. CMFB BLOCK (x3) ---'
echo '--------------------------------------------------------------------------'
print @n.x3.xm14.nsg13_lv_pmos[vds]    @n.x3.xm14.nsg13_lv_pmos[vgs]    @n.x3.xm14.nsg13_lv_pmos[vth]    @n.x3.xm14.nsg13_lv_pmos[ids]
echo '--------------------------------------------------------------------------'
print @n.x3.xm16.nsg13_lv_pmos[vds]    @n.x3.xm16.nsg13_lv_pmos[vgs]    @n.x3.xm16.nsg13_lv_pmos[vth]    @n.x3.xm16.nsg13_lv_pmos[ids]
echo '--------------------------------------------------------------------------'
print @n.x3.xm20.nsg13_lv_nmos[vds]    @n.x3.xm20.nsg13_lv_nmos[vgs]    @n.x3.xm20.nsg13_lv_nmos[vth]    @n.x3.xm20.nsg13_lv_nmos[ids]

echo '=========================================================================='
echo '--- 3. BIAS BLOCK (x1) ---'
echo '--------------------------------------------------------------------------'
print @n.x1.xm2.nsg13_lv_pmos[vds]     @n.x1.xm2.nsg13_lv_pmos[vgs]     @n.x1.xm2.nsg13_lv_pmos[vth]     @n.x1.xm2.nsg13_lv_pmos[ids]
echo '--------------------------------------------------------------------------'
print @n.x1.xm1.nsg13_lv_nmos[vds]     @n.x1.xm1.nsg13_lv_nmos[vgs]     @n.x1.xm1.nsg13_lv_nmos[vth]     @n.x1.xm1.nsg13_lv_nmos[ids]
echo '--------------------------------------------------------------------------'
print @n.x1.xm10.nsg13_lv_nmos[vds]    @n.x1.xm10.nsg13_lv_nmos[vgs]    @n.x1.xm10.nsg13_lv_nmos[vth]    @n.x1.xm10.nsg13_lv_nmos[ids]
echo '--------------------------------------------------------------------------'
print @n.x1.xm11.nsg13_lv_nmos[vds]    @n.x1.xm11.nsg13_lv_nmos[vgs]    @n.x1.xm11.nsg13_lv_nmos[vth]    @n.x1.xm11.nsg13_lv_nmos[ids]

echo '=========================================================================='
echo '          A2. VERIFY OUTPUT COMMON-MODE VOLTAGE (TARGET: 0.6V)'
echo '=========================================================================='
let v_cm_out = (v(vop) + v(von)) / 2
let v_diff_offset = v(vop) - v(von)
print v(vop) v(von) v_cm_out v_diff_offset

echo '=========================================================================='
echo '          A3. REPORT QUIESCENT CURRENT AND POWER CONSUMPTION'
echo '=========================================================================='
* Dong qua tung khoi tinh tu ids cua cac transistor nguon cap (Top PMOS):
let i_cascode = abs(@n.x2.xm0.nsg13_lv_pmos[ids])
let i_cs      = abs(@n.x2.xm_cs1.nsg13_lv_pmos[ids]) + abs(@n.x2.xm_cs2.nsg13_lv_pmos[ids])
let i_cmfb    = abs(@n.x3.xm14.nsg13_lv_pmos[ids]) + abs(@n.x3.xm15.nsg13_lv_pmos[ids])
let i_bias    = abs(@n.x1.xm2.nsg13_lv_pmos[ids]) + abs(@n.x1.xm4.nsg13_lv_pmos[ids]) + abs(@n.x1.xm8.nsg13_lv_pmos[ids])

let p_cascode = i_cascode * 1.2
let p_cs      = i_cs * 1.2
let p_cmfb    = i_cmfb * 1.2
let p_bias    = i_bias * 1.2

let i_total   = i_cascode + i_cs + i_cmfb + i_bias
let p_total   = i_total * 1.2

print i_cascode p_cascode
print i_cs p_cs
print i_cmfb p_cmfb
print i_bias p_bias
print i_total p_total

.endc

**** end user architecture code
**.ends

* expanding   symbol:  BIAS_Block/BIAS_Block.sym # of pins=7
** sym_path: /home/tundzi-lp1710/LAYOUT_ANALOG_FALL_DTVT/DO_AN_BAO_CAO/All_Block/BIAS_Block/BIAS_Block.sym
** sch_path: /home/tundzi-lp1710/LAYOUT_ANALOG_FALL_DTVT/DO_AN_BAO_CAO/All_Block/BIAS_Block/BIAS_Block.sch
.subckt BIAS_Block VSS V_BIAS4 V_BIAS2 V_BIAS3 VDD V_BIAS1 V_BIAS
*.iopin VSS
*.opin V_BIAS4
*.opin V_BIAS2
*.opin V_BIAS3
*.iopin VDD
*.opin V_BIAS1
*.ipin V_BIAS
XM1 net1 net1 net2 VSS sg13_lv_nmos w=4.4u l=0.3u ng=4
XM9 V_BIAS3 V_BIAS2 net4 VDD sg13_lv_pmos w=13.2u l=0.3u ng=4
XM10 V_BIAS3 V_BIAS3 V_BIAS4 VSS sg13_lv_nmos w=4.4u l=0.3u ng=4
XM11 V_BIAS4 V_BIAS4 VSS VSS sg13_lv_nmos w=3.3u l=0.3u ng=3
XM8 net4 V_BIAS1 VDD VDD sg13_lv_pmos w=13.2u l=0.3u ng=4
XM6 V_BIAS2 net1 net3 VSS sg13_lv_nmos w=4.4u l=0.3u ng=4
XM2 net1 V_BIAS VDD VDD sg13_lv_pmos w=13.2u l=0.3u ng=4
XM7 net3 net2 VSS VSS sg13_lv_nmos w=4.4u l=0.3u ng=4
XM4 V_BIAS1 V_BIAS1 VDD VDD sg13_lv_pmos w=13.2u l=0.3u ng=4
XM5 V_BIAS2 V_BIAS2 V_BIAS1 VDD sg13_lv_pmos w=13.2u l=0.3u ng=4
XM3 net2 net2 VSS VSS sg13_lv_nmos w=4.4u l=0.3u ng=4
.ends

* expanding   symbol:  CASCODE_Block/CASCODE_Block.sym # of pins=13
** sym_path: /home/tundzi-lp1710/LAYOUT_ANALOG_FALL_DTVT/DO_AN_BAO_CAO/All_Block/CASCODE_Block/CASCODE_Block.sym
** sch_path: /home/tundzi-lp1710/LAYOUT_ANALOG_FALL_DTVT/DO_AN_BAO_CAO/All_Block/CASCODE_Block/CASCODE_Block.sch
.subckt CASCODE_Block VDD V_BIAS1 V_IN V_IP V_BIAS2 V_ON1 V_OP1 V_BIAS3 V_ON2 V_OP2 VCMFBG V_BIAS4 VSS
*.iopin VDD
*.ipin V_IN
*.ipin V_IP
*.iopin VSS
*.ipin V_BIAS2
*.ipin V_BIAS1
*.ipin VCMFBG
*.opin V_ON1
*.opin V_OP1
*.ipin V_BIAS3
*.ipin V_BIAS4
*.opin V_ON2
*.opin V_OP2
XM5 V_ON1 V_BIAS3 net4 VSS sg13_lv_nmos w=30u l=0.5u ng=10
XM6 V_OP1 V_BIAS3 net5 VSS sg13_lv_nmos w=30u l=0.5u ng=10
XM7 net4 VCMFBG VSS VSS sg13_lv_nmos w=30u l=0.6u ng=10
XM8 net5 VCMFBG VSS VSS sg13_lv_nmos w=30u l=0.6u ng=10
XM1 net2 V_IN net1 VDD sg13_lv_pmos w=120u l=0.45u ng=40 m=2
XM2 net3 V_IP net1 VDD sg13_lv_pmos w=120u l=0.45u ng=40 m=2
XM3 V_ON1 V_BIAS2 net2 VDD sg13_lv_pmos w=135u l=0.5u ng=45
XM4 V_OP1 V_BIAS2 net3 VDD sg13_lv_pmos w=135u l=0.5u ng=45
XM0 net1 V_BIAS1 VDD VDD sg13_lv_pmos w=120u l=0.45u ng=40
XM_CS1 V_ON2 V_ON1 VDD VDD sg13_lv_pmos w=120u l=0.5u ng=40
XM_CS2 V_OP2 V_OP1 VDD VDD sg13_lv_pmos w=120u l=0.5u ng=40
XM_L1 V_ON2 V_BIAS4 VSS VSS sg13_lv_nmos w=80u l=0.5u ng=10
XM_L2 V_OP2 V_BIAS4 VSS VSS sg13_lv_nmos w=80u l=0.5u ng=10
R2 V_ON1 net6 0.9k
C1 net6 V_ON2 3p
R1 V_OP1 net7 0.9k
C2 net7 V_OP2 3p
.ends

* expanding   symbol:  CMFB_Block/CMFB_Block.sym # of pins=8
** sym_path: /home/tundzi-lp1710/LAYOUT_ANALOG_FALL_DTVT/DO_AN_BAO_CAO/All_Block/CMFB_Block/CMFB_Block.sym
** sch_path: /home/tundzi-lp1710/LAYOUT_ANALOG_FALL_DTVT/DO_AN_BAO_CAO/All_Block/CMFB_Block/CMFB_Block.sch
.subckt CMFB_Block VDD V_BIAS1 VCM V_OP V_ON VCMFBL VCMFBG VSS
*.ipin V_OP
*.ipin V_ON
*.ipin V_BIAS1
*.iopin VCMFBL
*.iopin VCMFBG
*.iopin VSS
*.iopin VDD
*.iopin VCM
XM14 net2 V_BIAS1 VDD VDD sg13_lv_pmos w=48.0u l=0.3u ng=16
XM15 net1 V_BIAS1 VDD VDD sg13_lv_pmos w=48.0u l=0.3u ng=16
XM16 VCMFBG V_OP net1 VDD sg13_lv_pmos w=7.2u l=0.3u ng=6
XM17 VCMFBL VCM net1 VDD sg13_lv_pmos w=7.2u l=0.3u ng=6
XM18 VCMFBL VCM net2 VDD sg13_lv_pmos w=7.2u l=0.3u ng=6
XM19 VCMFBG V_ON net2 VDD sg13_lv_pmos w=7.2u l=0.3u ng=6
XM20 VCMFBL VCMFBL VSS VSS sg13_lv_nmos w=7.2u l=0.3u ng=6
XM21 VCMFBG VCMFBG VSS VSS sg13_lv_nmos w=7.2u l=0.3u ng=6
.ends

.end
