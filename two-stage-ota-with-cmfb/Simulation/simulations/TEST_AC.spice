** sch_path: /home/tundzi-lp1710/LAYOUT_ANALOG_FALL_DTVT/DO_AN_BAO_CAO/All_Block/TEST_AC.sch
**.subckt TEST_AC
VDD VDD VSS 1.2
VSS VSS 0 0.0
V_IN V_IN VSS DC 0.6 AC -1.0
V_IP V_IP VSS DC 0.6 AC 1.0
V_BIAS V_BIAS VSS DC 0.7
V_BIAS1 VCM VSS DC 0.4
CL1 VOP VON 2p
x1 VSS V_BIAS4 V_BIAS2 V_BIAS3 VDD V_BIAS1 V_BIAS BIAS_Block
x2 VDD V_BIAS1 V_IN V_IP V_BIAS2 V_ON1 V_OP1 V_BIAS1 VON VOP VCMFBG V_BIAS4 VSS CASCODE_Block
x3 VDD V_BIAS1 VCM VOP VON VCMFBL VCMFBG VSS CMFB_Block
**** begin user architecture code

.lib cornerMOSlv.lib mos_tt

* ==============================================================================
* TESTBENCH CHO MUC B: AC ANALYSIS (OPEN-LOOP, DIFFERENTIAL MODE)
* ==============================================================================

.control
set color0=white
set color1=black

echo '=========================================================================='
echo '  B1 & B2. DIFFERENTIAL OPEN-LOOP AC ANALYSIS (BODE, GAIN, GBW, PM, GM)  '
echo '=========================================================================='

* 1. Thiet lap nguon vi sai: vip = +0.5V, vin = -0.5V (Total AC input = 1V)
alter @v_ip[acmag] = 0.5
alter @v_in[acmag] = -0.5
alter @vdd[acmag]  = 0.0
alter @vss[acmag]  = 0.0

* Chay phan tich AC tu 1 Hz den 10 GHz (10 diem/decade)
ac dec 20 1 10G

* Tinh do loi vi sai (Magnitude va Phase)
let v_out_diff = v(vop) - v(von)
let gain_db = db(v_out_diff)
let phase_deg = (180 / pi) * unwrap(ph(v_out_diff))

setplot ac1
let avd_db = gain_db
let f_axis = frequency

* --- Tu dong trich xuat cac thong so dac trung ---
* 1. DC Gain (Av0 o tan so thap nhat f = 1Hz)
let av0 = gain_db[0]

* 2. Tim UGF / GBW (Tan so ma Gain = 0 dB)
meas ac gbw when gain_db=0

* 3. Tim Phase Margin (PM = Phase tai tan so UGF - (-180))
* Luu y: Voi OTA dao pha 180 do o tan so thap, PM thuong tinh bang: 180 + phase
meas ac phase_at_ugf find phase_deg when gain_db=0
let pm = 180 + phase_at_ugf

* 4. Tim Gain Margin (GM: Do sut giam Gain khi Pha cham -180 do)
meas ac f_180 when phase_deg=-180
meas ac gain_at_180 find gain_db when phase_deg=-180
let gm = -gain_at_180

echo '--------------------------------------------------------------------------'
echo '                    KET QUA TRICH XUAT OPEN-LOOP AC                       '
echo '--------------------------------------------------------------------------'
print av0
print gbw
print pm
print gm
echo '--------------------------------------------------------------------------'

* Ve do thi Bode Plot (Magnitude & Phase)
plot gain_db ylabel 'Magnitude (dB)' title 'Bode Plot: Differential Gain'
plot phase_deg ylabel 'Phase (Degrees)' title 'Bode Plot: Differential Phase'

echo '=========================================================================='
echo '  B3. COMMON-MODE REJECTION RATIO (CMRR vs. FREQUENCY)                   '
echo '=========================================================================='

* 2. Thiet lap nguon che do chung: vip = 1V, vin = 1V
alter @v_ip[acmag] = 1.0
alter @v_in[acmag] = 1.0
alter @vdd[acmag]  = 0.0
alter @vss[acmag]  = 0.0

ac dec 20 1 10G

* Do loi che do chung (Common-Mode Gain)
let v_out_cm = v(vop) - v(von)
let avc_db = db(v_out_cm)

* Tinh CMRR (dB) = Avd(dB) - Avc(dB)
let cmrr_db = ac1.avd_db - avc_db

meas ac cmrr_dc find cmrr_db at=1
meas ac cmrr_1mhz find cmrr_db at=1Meg

echo '--------------------------------------------------------------------------'
print cmrr_dc cmrr_1mhz
echo '--------------------------------------------------------------------------'

plot cmrr_db ylabel 'CMRR (dB)' title 'Common-Mode Rejection Ratio (CMRR) vs. Frequency'

echo '=========================================================================='
echo '  B3. POWER SUPPLY REJECTION RATIO (PSRR vs. FREQUENCY)                  '
echo '=========================================================================='

* --- a. PSRR cua nguon VDD ---
* Tat AC ngo vao, kich thich nguon VDD
alter @v_ip[acmag] = 0.0
alter @v_in[acmag] = 0.0
alter @vdd[acmag]  = 1.0
alter @vss[acmag]  = 0.0

ac dec 20 1 10G

let v_out_vdd = v(vop) - v(von)
let a_vdd_db = db(v_out_vdd)
let psrr_vdd_db = ac1.avd_db - a_vdd_db

meas ac psrr_vdd_dc find psrr_vdd_db at=1
meas ac psrr_vdd_1mhz find psrr_vdd_db at=1Meg

echo '--------------------------------------------------------------------------'
echo 'PSRR+ (VDD):'
print psrr_vdd_dc psrr_vdd_1mhz
echo '--------------------------------------------------------------------------'

plot psrr_vdd_db ylabel 'PSRR VDD (dB)' title 'PSRR+ (VDD) vs. Frequency'

* --- b. PSRR cua nguon VSS ---
* Tat AC VDD, kich thich nguon VSS
alter @vdd[acmag]  = 0.0
alter @vss[acmag]  = 1.0

ac dec 20 1 10G

let v_out_vss = v(vop) - v(von)
let a_vss_db = db(v_out_vss)
let psrr_vss_db = ac1.avd_db - a_vss_db

meas ac psrr_vss_dc find psrr_vss_db at=1
meas ac psrr_vss_1mhz find psrr_vss_db at=1Meg

echo '--------------------------------------------------------------------------'
echo 'PSRR- (VSS):'
print psrr_vss_dc psrr_vss_1mhz
echo '--------------------------------------------------------------------------'

plot psrr_vss_db ylabel 'PSRR VSS (dB)' title 'PSRR- (VSS) vs. Frequency'

.endc

**** end user architecture code
**.ends

* expanding   symbol:  BIAS_Block/BIAS_Block.sym # of pins=7
** sym_path: /home/tundzi-lp1710/LAYOUT_ANALOG_FALL_DTVT/DO_AN_BAO_CAO/All_Block/BIAS_Block/BIAS_Block.sym
** sch_path: /home/tundzi-lp1710/LAYOUT_ANALOG_FALL_DTVT/DO_AN_BAO_CAO/All_Block/BIAS_Block/BIAS_Block.sch
.subckt BIAS_Block VSS V_BIAS4 V_BIAS2 V_BIAS3 VDD V_BIAS1 V_BIAS
*.iopin VSS
*.opin V_BIAS4
*.opin V_BIAS2
*.opin V_BIAS3
*.iopin VDD
*.opin V_BIAS1
*.ipin V_BIAS
XM1 net1 net1 net2 VSS sg13_lv_nmos w=4.4u l=0.3u ng=4
XM9 V_BIAS3 V_BIAS2 net4 VDD sg13_lv_pmos w=13.2u l=0.3u ng=4
XM10 V_BIAS3 V_BIAS3 V_BIAS4 VSS sg13_lv_nmos w=4.4u l=0.3u ng=4
XM11 V_BIAS4 V_BIAS4 VSS VSS sg13_lv_nmos w=3.3u l=0.3u ng=3
XM8 net4 V_BIAS1 VDD VDD sg13_lv_pmos w=13.2u l=0.3u ng=4
XM6 V_BIAS2 net1 net3 VSS sg13_lv_nmos w=4.4u l=0.3u ng=4
XM2 net1 V_BIAS VDD VDD sg13_lv_pmos w=13.2u l=0.3u ng=4
XM7 net3 net2 VSS VSS sg13_lv_nmos w=4.4u l=0.3u ng=4
XM4 V_BIAS1 V_BIAS1 VDD VDD sg13_lv_pmos w=13.2u l=0.3u ng=4
XM5 V_BIAS2 V_BIAS2 V_BIAS1 VDD sg13_lv_pmos w=13.2u l=0.3u ng=4
XM3 net2 net2 VSS VSS sg13_lv_nmos w=4.4u l=0.3u ng=4
.ends

* expanding   symbol:  CASCODE_Block/CASCODE_Block.sym # of pins=13
** sym_path: /home/tundzi-lp1710/LAYOUT_ANALOG_FALL_DTVT/DO_AN_BAO_CAO/All_Block/CASCODE_Block/CASCODE_Block.sym
** sch_path: /home/tundzi-lp1710/LAYOUT_ANALOG_FALL_DTVT/DO_AN_BAO_CAO/All_Block/CASCODE_Block/CASCODE_Block.sch
.subckt CASCODE_Block VDD V_BIAS1 V_IN V_IP V_BIAS2 V_ON1 V_OP1 V_BIAS3 V_ON2 V_OP2 VCMFBG V_BIAS4 VSS
*.iopin VDD
*.ipin V_IN
*.ipin V_IP
*.iopin VSS
*.ipin V_BIAS2
*.ipin V_BIAS1
*.ipin VCMFBG
*.opin V_ON1
*.opin V_OP1
*.ipin V_BIAS3
*.ipin V_BIAS4
*.opin V_ON2
*.opin V_OP2
XM5 V_ON1 V_BIAS3 net4 VSS sg13_lv_nmos w=30u l=0.5u ng=10
XM6 V_OP1 V_BIAS3 net5 VSS sg13_lv_nmos w=30u l=0.5u ng=10
XM7 net4 VCMFBG VSS VSS sg13_lv_nmos w=30u l=0.6u ng=10
XM8 net5 VCMFBG VSS VSS sg13_lv_nmos w=30u l=0.6u ng=10
XM1 net2 V_IN net1 VDD sg13_lv_pmos w=120u l=0.45u ng=40 m=2
XM2 net3 V_IP net1 VDD sg13_lv_pmos w=120u l=0.45u ng=40 m=2
XM3 V_ON1 V_BIAS2 net2 VDD sg13_lv_pmos w=135u l=0.5u ng=45
XM4 V_OP1 V_BIAS2 net3 VDD sg13_lv_pmos w=135u l=0.5u ng=45
XM0 net1 V_BIAS1 VDD VDD sg13_lv_pmos w=120u l=0.45u ng=40
XM_CS1 V_ON2 V_ON1 VDD VDD sg13_lv_pmos w=120u l=0.5u ng=40
XM_CS2 V_OP2 V_OP1 VDD VDD sg13_lv_pmos w=120u l=0.5u ng=40
XM_L1 V_ON2 V_BIAS4 VSS VSS sg13_lv_nmos w=80u l=0.5u ng=10
XM_L2 V_OP2 V_BIAS4 VSS VSS sg13_lv_nmos w=80u l=0.5u ng=10
R2 V_ON1 net6 0.9k
C1 net6 V_ON2 3p
R1 V_OP1 net7 0.9k
C2 net7 V_OP2 3p
.ends

* expanding   symbol:  CMFB_Block/CMFB_Block.sym # of pins=8
** sym_path: /home/tundzi-lp1710/LAYOUT_ANALOG_FALL_DTVT/DO_AN_BAO_CAO/All_Block/CMFB_Block/CMFB_Block.sym
** sch_path: /home/tundzi-lp1710/LAYOUT_ANALOG_FALL_DTVT/DO_AN_BAO_CAO/All_Block/CMFB_Block/CMFB_Block.sch
.subckt CMFB_Block VDD V_BIAS1 VCM V_OP V_ON VCMFBL VCMFBG VSS
*.ipin V_OP
*.ipin V_ON
*.ipin V_BIAS1
*.iopin VCMFBL
*.iopin VCMFBG
*.iopin VSS
*.iopin VDD
*.iopin VCM
XM14 net2 V_BIAS1 VDD VDD sg13_lv_pmos w=48.0u l=0.3u ng=16
XM15 net1 V_BIAS1 VDD VDD sg13_lv_pmos w=48.0u l=0.3u ng=16
XM16 VCMFBG V_OP net1 VDD sg13_lv_pmos w=7.2u l=0.3u ng=6
XM17 VCMFBL VCM net1 VDD sg13_lv_pmos w=7.2u l=0.3u ng=6
XM18 VCMFBL VCM net2 VDD sg13_lv_pmos w=7.2u l=0.3u ng=6
XM19 VCMFBG V_ON net2 VDD sg13_lv_pmos w=7.2u l=0.3u ng=6
XM20 VCMFBL VCMFBL VSS VSS sg13_lv_nmos w=7.2u l=0.3u ng=6
XM21 VCMFBG VCMFBG VSS VSS sg13_lv_nmos w=7.2u l=0.3u ng=6
.ends

.end
