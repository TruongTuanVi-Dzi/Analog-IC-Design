* NGSPICE file created from CASCODE_Block.ext - technology: ihp-sg13g2

.subckt pmos a_1064_n36# a_2060_n36# a_3056_n36# a_2316_0# a_68_n36# a_2980_0# a_1396_n36#
+ a_2392_n36# w_n62_n62# a_2648_0# a_1230_n36# a_2814_0# a_490_0# a_234_n36# a_1154_0#
+ a_2226_n36# a_3222_n36# sub a_1320_0# a_3146_0# a_158_0# a_1562_n36# a_3312_0# a_324_0#
+ a_566_n36# a_1486_0# a_2558_n36# a_1652_0# a_400_n36# a_2890_n36# a_1894_n36# a_656_0#
+ a_898_n36# a_822_0# a_2150_0# a_1984_0# a_0_0# a_732_n36# a_1728_n36# a_988_0# a_2724_n36#
+ a_2482_0# a_1818_0#
X0 a_2150_0# a_2060_n36# a_1984_0# w_n62_n62# sg13_lv_pmos ad=0.57p pd=3.38u as=0.57p ps=3.38u w=3u l=0.45u
X1 a_324_0# a_234_n36# a_158_0# w_n62_n62# sg13_lv_pmos ad=0.57p pd=3.38u as=0.57p ps=3.38u w=3u l=0.45u
X2 a_1154_0# a_1064_n36# a_988_0# w_n62_n62# sg13_lv_pmos ad=0.57p pd=3.38u as=0.57p ps=3.38u w=3u l=0.45u
X3 a_2814_0# a_2724_n36# a_2648_0# w_n62_n62# sg13_lv_pmos ad=0.57p pd=3.38u as=0.57p ps=3.38u w=3u l=0.45u
X4 a_1818_0# a_1728_n36# a_1652_0# w_n62_n62# sg13_lv_pmos ad=0.57p pd=3.38u as=0.57p ps=3.38u w=3u l=0.45u
X5 a_2980_0# a_2890_n36# a_2814_0# w_n62_n62# sg13_lv_pmos ad=0.57p pd=3.38u as=0.57p ps=3.38u w=3u l=0.45u
X6 a_1984_0# a_1894_n36# a_1818_0# w_n62_n62# sg13_lv_pmos ad=0.57p pd=3.38u as=0.57p ps=3.38u w=3u l=0.45u
X7 a_2648_0# a_2558_n36# a_2482_0# w_n62_n62# sg13_lv_pmos ad=0.57p pd=3.38u as=0.57p ps=3.38u w=3u l=0.45u
X8 a_822_0# a_732_n36# a_656_0# w_n62_n62# sg13_lv_pmos ad=0.57p pd=3.38u as=0.57p ps=3.38u w=3u l=0.45u
X9 a_1652_0# a_1562_n36# a_1486_0# w_n62_n62# sg13_lv_pmos ad=0.57p pd=3.38u as=0.57p ps=3.38u w=3u l=0.45u
X10 a_3312_0# a_3222_n36# a_3146_0# w_n62_n62# sg13_lv_pmos ad=1.02p pd=6.68u as=0.57p ps=3.38u w=3u l=0.45u
X11 a_988_0# a_898_n36# a_822_0# w_n62_n62# sg13_lv_pmos ad=0.57p pd=3.38u as=0.57p ps=3.38u w=3u l=0.45u
X12 a_2316_0# a_2226_n36# a_2150_0# w_n62_n62# sg13_lv_pmos ad=0.57p pd=3.38u as=0.57p ps=3.38u w=3u l=0.45u
X13 a_490_0# a_400_n36# a_324_0# w_n62_n62# sg13_lv_pmos ad=0.57p pd=3.38u as=0.57p ps=3.38u w=3u l=0.45u
X14 a_1320_0# a_1230_n36# a_1154_0# w_n62_n62# sg13_lv_pmos ad=0.57p pd=3.38u as=0.57p ps=3.38u w=3u l=0.45u
X15 a_158_0# a_68_n36# a_0_0# w_n62_n62# sg13_lv_pmos ad=0.57p pd=3.38u as=1.02p ps=6.68u w=3u l=0.45u
X16 a_2482_0# a_2392_n36# a_2316_0# w_n62_n62# sg13_lv_pmos ad=0.57p pd=3.38u as=0.57p ps=3.38u w=3u l=0.45u
X17 a_656_0# a_566_n36# a_490_0# w_n62_n62# sg13_lv_pmos ad=0.57p pd=3.38u as=0.57p ps=3.38u w=3u l=0.45u
X18 a_1486_0# a_1396_n36# a_1320_0# w_n62_n62# sg13_lv_pmos ad=0.57p pd=3.38u as=0.57p ps=3.38u w=3u l=0.45u
X19 a_3146_0# a_3056_n36# a_2980_0# w_n62_n62# sg13_lv_pmos ad=0.57p pd=3.38u as=0.57p ps=3.38u w=3u l=0.45u
C0 a_1154_0# a_1064_n36# 0.05194f
C1 a_234_n36# w_n62_n62# 0.14988f
C2 a_1818_0# w_n62_n62# 0.03003f
C3 a_234_n36# a_324_0# 0.05194f
C4 a_158_0# a_234_n36# 0.05194f
C5 a_1486_0# w_n62_n62# 0.03003f
C6 a_656_0# a_490_0# 0.08399f
C7 a_1818_0# a_1728_n36# 0.05194f
C8 a_2558_n36# a_2648_0# 0.05194f
C9 a_2980_0# a_2814_0# 0.08399f
C10 a_1320_0# w_n62_n62# 0.03003f
C11 a_2980_0# w_n62_n62# 0.03003f
C12 a_822_0# a_988_0# 0.08399f
C13 a_1064_n36# w_n62_n62# 0.14988f
C14 a_988_0# a_898_n36# 0.05194f
C15 a_3056_n36# a_3146_0# 0.05194f
C16 a_566_n36# w_n62_n62# 0.14988f
C17 a_1652_0# a_1562_n36# 0.05194f
C18 a_1320_0# a_1230_n36# 0.05194f
C19 a_3312_0# a_3146_0# 0.08399f
C20 a_2814_0# a_2648_0# 0.08399f
C21 w_n62_n62# a_2648_0# 0.03003f
C22 a_2316_0# w_n62_n62# 0.03003f
C23 a_822_0# w_n62_n62# 0.03003f
C24 a_1652_0# w_n62_n62# 0.03003f
C25 a_1320_0# a_1486_0# 0.08399f
C26 a_898_n36# w_n62_n62# 0.14988f
C27 a_68_n36# w_n62_n62# 0.15256f
C28 a_1894_n36# a_1984_0# 0.05194f
C29 a_3146_0# w_n62_n62# 0.03003f
C30 a_2150_0# a_1984_0# 0.08399f
C31 a_2648_0# a_2724_n36# 0.05194f
C32 a_3312_0# a_3222_n36# 0.05194f
C33 w_n62_n62# a_656_0# 0.03003f
C34 a_1652_0# a_1728_n36# 0.05194f
C35 a_2482_0# a_2648_0# 0.08399f
C36 a_400_n36# a_490_0# 0.05194f
C37 a_2482_0# a_2316_0# 0.08399f
C38 a_68_n36# a_0_0# 0.05194f
C39 a_68_n36# a_158_0# 0.05194f
C40 a_1894_n36# w_n62_n62# 0.14988f
C41 w_n62_n62# a_2392_n36# 0.14988f
C42 a_2316_0# a_2226_n36# 0.05194f
C43 a_2150_0# w_n62_n62# 0.03003f
C44 a_2890_n36# a_2814_0# 0.05194f
C45 a_3222_n36# w_n62_n62# 0.15256f
C46 a_2890_n36# w_n62_n62# 0.14988f
C47 a_732_n36# w_n62_n62# 0.14988f
C48 a_1818_0# a_1652_0# 0.08399f
C49 a_2482_0# a_2392_n36# 0.05194f
C50 a_2150_0# a_2060_n36# 0.05194f
C51 a_1154_0# a_988_0# 0.08399f
C52 a_1652_0# a_1486_0# 0.08399f
C53 w_n62_n62# a_490_0# 0.03003f
C54 a_2150_0# a_2226_n36# 0.05194f
C55 a_1894_n36# a_1818_0# 0.05194f
C56 a_324_0# a_490_0# 0.08399f
C57 a_2980_0# a_3146_0# 0.08399f
C58 a_1396_n36# w_n62_n62# 0.14988f
C59 a_2558_n36# w_n62_n62# 0.14988f
C60 a_988_0# w_n62_n62# 0.03003f
C61 a_400_n36# w_n62_n62# 0.14988f
C62 a_3056_n36# w_n62_n62# 0.14988f
C63 a_1154_0# w_n62_n62# 0.03003f
C64 a_566_n36# a_656_0# 0.05194f
C65 a_2890_n36# a_2980_0# 0.05194f
C66 a_400_n36# a_324_0# 0.05194f
C67 a_2558_n36# a_2482_0# 0.05194f
C68 a_1562_n36# w_n62_n62# 0.14988f
C69 a_3312_0# w_n62_n62# 0.03341f
C70 w_n62_n62# a_1984_0# 0.03003f
C71 a_822_0# a_898_n36# 0.05194f
C72 a_2814_0# w_n62_n62# 0.03003f
C73 a_822_0# a_656_0# 0.08399f
C74 a_1396_n36# a_1486_0# 0.05194f
C75 a_2060_n36# a_1984_0# 0.05194f
C76 a_1230_n36# a_1154_0# 0.05194f
C77 a_2316_0# a_2392_n36# 0.05194f
C78 a_1320_0# a_1396_n36# 0.05194f
C79 a_2150_0# a_2316_0# 0.08399f
C80 a_2814_0# a_2724_n36# 0.05194f
C81 a_1728_n36# w_n62_n62# 0.14988f
C82 w_n62_n62# a_0_0# 0.03341f
C83 w_n62_n62# a_324_0# 0.03003f
C84 a_566_n36# a_490_0# 0.05194f
C85 a_158_0# w_n62_n62# 0.03003f
C86 w_n62_n62# a_2724_n36# 0.14988f
C87 a_2060_n36# w_n62_n62# 0.14988f
C88 a_822_0# a_732_n36# 0.05194f
C89 a_1818_0# a_1984_0# 0.08399f
C90 a_2482_0# w_n62_n62# 0.03003f
C91 a_1064_n36# a_988_0# 0.05194f
C92 a_3146_0# a_3222_n36# 0.05194f
C93 a_3056_n36# a_2980_0# 0.05194f
C94 a_1486_0# a_1562_n36# 0.05194f
C95 a_158_0# a_0_0# 0.08399f
C96 w_n62_n62# a_2226_n36# 0.14988f
C97 a_158_0# a_324_0# 0.08399f
C98 a_1320_0# a_1154_0# 0.08399f
C99 a_1230_n36# w_n62_n62# 0.14988f
C100 a_732_n36# a_656_0# 0.05194f
C101 a_3312_0# sub 0.13091f
C102 a_3146_0# sub 0.04901f
C103 a_2980_0# sub 0.04532f
C104 a_2814_0# sub 0.04532f
C105 a_2648_0# sub 0.04532f
C106 a_2482_0# sub 0.04532f
C107 a_2316_0# sub 0.04532f
C108 a_2150_0# sub 0.04532f
C109 a_1984_0# sub 0.04532f
C110 a_1818_0# sub 0.04532f
C111 a_1652_0# sub 0.04532f
C112 a_1486_0# sub 0.04532f
C113 a_1320_0# sub 0.04532f
C114 a_1154_0# sub 0.04532f
C115 a_988_0# sub 0.04532f
C116 a_822_0# sub 0.04532f
C117 a_656_0# sub 0.04532f
C118 a_490_0# sub 0.04532f
C119 a_324_0# sub 0.04532f
C120 a_158_0# sub 0.04901f
C121 a_0_0# sub 0.13091f
.ends

.subckt nmos$2 a_68_n36# a_656_n36# a_580_0# a_384_0# a_188_0# sub a_264_n36# a_972_0#
+ a_776_0# a_852_n36# a_0_0# a_460_n36#
X0 a_776_0# a_656_n36# a_580_0# sub sg13_lv_nmos ad=0.57p pd=3.38u as=0.57p ps=3.38u w=3u l=0.6u
X1 a_580_0# a_460_n36# a_384_0# sub sg13_lv_nmos ad=0.57p pd=3.38u as=0.57p ps=3.38u w=3u l=0.6u
X2 a_972_0# a_852_n36# a_776_0# sub sg13_lv_nmos ad=1.02p pd=6.68u as=0.57p ps=3.38u w=3u l=0.6u
X3 a_188_0# a_68_n36# a_0_0# sub sg13_lv_nmos ad=0.57p pd=3.38u as=1.02p ps=6.68u w=3u l=0.6u
X4 a_384_0# a_264_n36# a_188_0# sub sg13_lv_nmos ad=0.57p pd=3.38u as=0.57p ps=3.38u w=3u l=0.6u
C0 a_776_0# a_656_n36# 0.06311f
C1 a_264_n36# a_384_0# 0.06311f
C2 a_384_0# a_188_0# 0.06819f
C3 a_776_0# a_972_0# 0.06819f
C4 a_776_0# a_580_0# 0.06819f
C5 a_776_0# a_852_n36# 0.06311f
C6 a_580_0# a_656_n36# 0.06311f
C7 a_460_n36# a_580_0# 0.06311f
C8 a_68_n36# a_188_0# 0.06311f
C9 a_264_n36# a_188_0# 0.06311f
C10 a_460_n36# a_384_0# 0.06311f
C11 a_852_n36# a_972_0# 0.06311f
C12 a_0_0# a_68_n36# 0.06311f
C13 a_384_0# a_580_0# 0.06819f
C14 a_0_0# a_188_0# 0.06819f
C15 a_972_0# sub 0.25358f
C16 a_776_0# sub 0.25937f
C17 a_580_0# sub 0.25435f
C18 a_384_0# sub 0.25435f
C19 a_188_0# sub 0.25937f
C20 a_0_0# sub 0.25358f
.ends

.subckt pmos$6 a_2280_0# a_3412_n36# a_1300_n36# a_2632_0# a_2708_n36# a_2004_n36#
+ a_3512_0# a_3160_0# a_1400_0# a_68_n36# a_344_0# w_n62_n62# a_872_0# a_3060_n36#
+ a_1652_n36# a_2356_n36# a_948_n36# a_244_n36# a_1048_0# sub a_520_0# a_1928_0# a_1576_0#
+ a_2532_n36# a_596_n36# a_2456_0# a_3236_n36# a_1828_n36# a_2808_0# a_1124_n36# a_420_n36#
+ a_3336_0# a_1224_0# a_168_0# a_2984_0# a_0_0# a_2104_0# a_1752_0# a_2884_n36# a_2180_n36#
+ a_696_0# a_1476_n36# a_772_n36#
X0 a_1048_0# a_948_n36# a_872_0# w_n62_n62# sg13_lv_pmos ad=0.57p pd=3.38u as=0.57p ps=3.38u w=3u l=0.5u
X1 a_1400_0# a_1300_n36# a_1224_0# w_n62_n62# sg13_lv_pmos ad=0.57p pd=3.38u as=0.57p ps=3.38u w=3u l=0.5u
X2 a_2808_0# a_2708_n36# a_2632_0# w_n62_n62# sg13_lv_pmos ad=0.57p pd=3.38u as=0.57p ps=3.38u w=3u l=0.5u
X3 a_3512_0# a_3412_n36# a_3336_0# w_n62_n62# sg13_lv_pmos ad=1.02p pd=6.68u as=0.57p ps=3.38u w=3u l=0.5u
X4 a_1576_0# a_1476_n36# a_1400_0# w_n62_n62# sg13_lv_pmos ad=0.57p pd=3.38u as=0.57p ps=3.38u w=3u l=0.5u
X5 a_2280_0# a_2180_n36# a_2104_0# w_n62_n62# sg13_lv_pmos ad=0.57p pd=3.38u as=0.57p ps=3.38u w=3u l=0.5u
X6 a_2984_0# a_2884_n36# a_2808_0# w_n62_n62# sg13_lv_pmos ad=0.57p pd=3.38u as=0.57p ps=3.38u w=3u l=0.5u
X7 a_1224_0# a_1124_n36# a_1048_0# w_n62_n62# sg13_lv_pmos ad=0.57p pd=3.38u as=0.57p ps=3.38u w=3u l=0.5u
X8 a_1928_0# a_1828_n36# a_1752_0# w_n62_n62# sg13_lv_pmos ad=0.57p pd=3.38u as=0.57p ps=3.38u w=3u l=0.5u
X9 a_3336_0# a_3236_n36# a_3160_0# w_n62_n62# sg13_lv_pmos ad=0.57p pd=3.38u as=0.57p ps=3.38u w=3u l=0.5u
X10 a_872_0# a_772_n36# a_696_0# w_n62_n62# sg13_lv_pmos ad=0.57p pd=3.38u as=0.57p ps=3.38u w=3u l=0.5u
X11 a_2632_0# a_2532_n36# a_2456_0# w_n62_n62# sg13_lv_pmos ad=0.57p pd=3.38u as=0.57p ps=3.38u w=3u l=0.5u
X12 a_520_0# a_420_n36# a_344_0# w_n62_n62# sg13_lv_pmos ad=0.57p pd=3.38u as=0.57p ps=3.38u w=3u l=0.5u
X13 a_696_0# a_596_n36# a_520_0# w_n62_n62# sg13_lv_pmos ad=0.57p pd=3.38u as=0.57p ps=3.38u w=3u l=0.5u
X14 a_2456_0# a_2356_n36# a_2280_0# w_n62_n62# sg13_lv_pmos ad=0.57p pd=3.38u as=0.57p ps=3.38u w=3u l=0.5u
X15 a_168_0# a_68_n36# a_0_0# w_n62_n62# sg13_lv_pmos ad=0.57p pd=3.38u as=1.02p ps=6.68u w=3u l=0.5u
X16 a_1752_0# a_1652_n36# a_1576_0# w_n62_n62# sg13_lv_pmos ad=0.57p pd=3.38u as=0.57p ps=3.38u w=3u l=0.5u
X17 a_3160_0# a_3060_n36# a_2984_0# w_n62_n62# sg13_lv_pmos ad=0.57p pd=3.38u as=0.57p ps=3.38u w=3u l=0.5u
X18 a_344_0# a_244_n36# a_168_0# w_n62_n62# sg13_lv_pmos ad=0.57p pd=3.38u as=0.57p ps=3.38u w=3u l=0.5u
X19 a_2104_0# a_2004_n36# a_1928_0# w_n62_n62# sg13_lv_pmos ad=0.57p pd=3.38u as=0.57p ps=3.38u w=3u l=0.5u
C0 a_3060_n36# a_2984_0# 0.05596f
C1 a_1752_0# a_1652_n36# 0.05596f
C2 a_1476_n36# a_1400_0# 0.05596f
C3 w_n62_n62# a_2708_n36# 0.1652f
C4 a_2808_0# a_2708_n36# 0.05596f
C5 a_2984_0# a_3160_0# 0.07802f
C6 w_n62_n62# a_1652_n36# 0.1652f
C7 a_2280_0# a_2104_0# 0.07802f
C8 a_1300_n36# w_n62_n62# 0.1652f
C9 a_1048_0# w_n62_n62# 0.03185f
C10 a_596_n36# w_n62_n62# 0.1652f
C11 a_3060_n36# a_3160_0# 0.05596f
C12 a_420_n36# a_344_0# 0.05596f
C13 w_n62_n62# a_3512_0# 0.03433f
C14 a_696_0# a_596_n36# 0.05596f
C15 a_2180_n36# w_n62_n62# 0.1652f
C16 a_3412_n36# a_3512_0# 0.05596f
C17 a_1400_0# a_1224_0# 0.07802f
C18 a_2632_0# a_2532_n36# 0.05596f
C19 a_3236_n36# a_3160_0# 0.05596f
C20 a_244_n36# a_344_0# 0.05596f
C21 a_2884_n36# w_n62_n62# 0.1652f
C22 a_2808_0# a_2884_n36# 0.05596f
C23 a_1576_0# a_1652_n36# 0.05596f
C24 a_2004_n36# a_2104_0# 0.05596f
C25 a_168_0# a_0_0# 0.07802f
C26 w_n62_n62# a_0_0# 0.03433f
C27 a_1048_0# a_948_n36# 0.05596f
C28 a_1752_0# a_1928_0# 0.07802f
C29 a_2456_0# w_n62_n62# 0.03185f
C30 a_1124_n36# w_n62_n62# 0.1652f
C31 a_872_0# w_n62_n62# 0.03185f
C32 a_520_0# w_n62_n62# 0.03185f
C33 a_696_0# a_872_0# 0.07802f
C34 a_68_n36# a_0_0# 0.05596f
C35 w_n62_n62# a_1928_0# 0.03185f
C36 w_n62_n62# a_3336_0# 0.03185f
C37 a_696_0# a_520_0# 0.07802f
C38 a_3412_n36# a_3336_0# 0.05596f
C39 a_2356_n36# a_2456_0# 0.05596f
C40 a_872_0# a_948_n36# 0.05596f
C41 a_1300_n36# a_1400_0# 0.05596f
C42 a_1752_0# w_n62_n62# 0.03185f
C43 a_2884_n36# a_2984_0# 0.05596f
C44 a_2180_n36# a_2104_0# 0.05596f
C45 a_1828_n36# a_1928_0# 0.05596f
C46 a_168_0# w_n62_n62# 0.03185f
C47 a_2456_0# a_2532_n36# 0.05596f
C48 a_2808_0# w_n62_n62# 0.03185f
C49 a_2632_0# a_2708_n36# 0.05596f
C50 w_n62_n62# a_3412_n36# 0.16788f
C51 a_696_0# w_n62_n62# 0.03185f
C52 a_2180_n36# a_2280_0# 0.05596f
C53 a_1300_n36# a_1224_0# 0.05596f
C54 a_1576_0# a_1752_0# 0.07802f
C55 a_68_n36# a_168_0# 0.05596f
C56 a_68_n36# w_n62_n62# 0.16788f
C57 a_1048_0# a_1224_0# 0.07802f
C58 a_520_0# a_344_0# 0.07802f
C59 a_2456_0# a_2280_0# 0.07802f
C60 a_1752_0# a_1828_n36# 0.05596f
C61 a_2356_n36# w_n62_n62# 0.1652f
C62 w_n62_n62# a_948_n36# 0.1652f
C63 a_1576_0# w_n62_n62# 0.03185f
C64 a_2104_0# a_1928_0# 0.07802f
C65 a_872_0# a_772_n36# 0.05596f
C66 a_3236_n36# a_3336_0# 0.05596f
C67 w_n62_n62# a_1828_n36# 0.1652f
C68 a_3336_0# a_3160_0# 0.07802f
C69 a_1124_n36# a_1224_0# 0.05596f
C70 a_2456_0# a_2632_0# 0.07802f
C71 a_520_0# a_420_n36# 0.05596f
C72 w_n62_n62# a_2984_0# 0.03185f
C73 a_2532_n36# w_n62_n62# 0.1652f
C74 a_168_0# a_344_0# 0.07802f
C75 w_n62_n62# a_344_0# 0.03185f
C76 a_2808_0# a_2984_0# 0.07802f
C77 w_n62_n62# a_1400_0# 0.03185f
C78 a_2004_n36# a_1928_0# 0.05596f
C79 a_1476_n36# w_n62_n62# 0.1652f
C80 a_2104_0# w_n62_n62# 0.03185f
C81 a_3060_n36# w_n62_n62# 0.1652f
C82 a_2280_0# w_n62_n62# 0.03185f
C83 w_n62_n62# a_3236_n36# 0.1652f
C84 a_772_n36# w_n62_n62# 0.1652f
C85 w_n62_n62# a_3160_0# 0.03185f
C86 a_696_0# a_772_n36# 0.05596f
C87 a_1576_0# a_1400_0# 0.07802f
C88 a_1576_0# a_1476_n36# 0.05596f
C89 w_n62_n62# a_420_n36# 0.1652f
C90 w_n62_n62# a_1224_0# 0.03185f
C91 a_1124_n36# a_1048_0# 0.05596f
C92 a_872_0# a_1048_0# 0.07802f
C93 a_2632_0# w_n62_n62# 0.03185f
C94 a_2356_n36# a_2280_0# 0.05596f
C95 a_244_n36# a_168_0# 0.05596f
C96 a_244_n36# w_n62_n62# 0.1652f
C97 a_2632_0# a_2808_0# 0.07802f
C98 a_2004_n36# w_n62_n62# 0.1652f
C99 a_520_0# a_596_n36# 0.05596f
C100 a_3336_0# a_3512_0# 0.07802f
C101 a_3512_0# sub 0.13282f
C102 a_3336_0# sub 0.05283f
C103 a_3160_0# sub 0.04914f
C104 a_2984_0# sub 0.04914f
C105 a_2808_0# sub 0.04914f
C106 a_2632_0# sub 0.04914f
C107 a_2456_0# sub 0.04914f
C108 a_2280_0# sub 0.04914f
C109 a_2104_0# sub 0.04914f
C110 a_1928_0# sub 0.04914f
C111 a_1752_0# sub 0.04914f
C112 a_1576_0# sub 0.04914f
C113 a_1400_0# sub 0.04914f
C114 a_1224_0# sub 0.04914f
C115 a_1048_0# sub 0.04914f
C116 a_872_0# sub 0.04914f
C117 a_696_0# sub 0.04914f
C118 a_520_0# sub 0.04914f
C119 a_344_0# sub 0.04914f
C120 a_168_0# sub 0.05283f
C121 a_0_0# sub 0.13282f
.ends

.subckt cmim$1 sub c1_0_0# m5_n120_n120#
X0 c1_0_0# m5_n120_n120# cap_cmim l=44.72u w=44.72u
C0 c1_0_0# m5_n120_n120# 2.97225f
C1 m5_n120_n120# sub 26.41474f
.ends

.subckt pmos$4 a_68_n36# w_n62_n62# sub a_168_0# a_0_0#
X0 a_168_0# a_68_n36# a_0_0# w_n62_n62# sg13_lv_pmos ad=1.02p pd=6.68u as=1.02p ps=6.68u w=3u l=0.5u
C0 a_0_0# a_168_0# 0.07802f
C1 a_0_0# w_n62_n62# 0.03433f
C2 a_168_0# w_n62_n62# 0.03433f
C3 a_0_0# a_68_n36# 0.05596f
C4 a_68_n36# a_168_0# 0.05596f
C5 a_68_n36# w_n62_n62# 0.17056f
C6 a_168_0# sub 0.1365f
C7 a_0_0# sub 0.1365f
.ends

.subckt pmos$2 a_68_n36# w_n62_n62# sub a_158_0# a_0_0#
X0 a_158_0# a_68_n36# a_0_0# w_n62_n62# sg13_lv_pmos ad=1.02p pd=6.68u as=1.02p ps=6.68u w=3u l=0.45u
C0 a_0_0# a_158_0# 0.08399f
C1 a_0_0# w_n62_n62# 0.03341f
C2 a_158_0# w_n62_n62# 0.03341f
C3 a_0_0# a_68_n36# 0.05194f
C4 a_68_n36# a_158_0# 0.05194f
C5 a_68_n36# w_n62_n62# 0.15524f
C6 a_158_0# sub 0.13459f
C7 a_0_0# sub 0.13459f
.ends

.subckt nmos$5 a_68_n36# sub a_168_0# a_0_0#
X0 a_168_0# a_68_n36# a_0_0# sub sg13_lv_nmos ad=1.02p pd=6.68u as=1.02p ps=6.68u w=3u l=0.5u
C0 a_168_0# a_68_n36# 0.05596f
C1 a_168_0# a_0_0# 0.07802f
C2 a_0_0# a_68_n36# 0.05596f
C3 a_168_0# sub 0.23946f
C4 a_0_0# sub 0.23946f
.ends

.subckt rppd$1 sub a_0_294# a_0_n86#
X0 a_0_294# a_0_n86# sub rppd l=1.47u w=0.5u
C0 a_0_n86# a_0_0# 0.01433f
C1 a_0_0# a_0_294# 0.01433f
C2 a_0_n86# sub 0.21872f
C3 a_0_294# sub 0.21872f
.ends

.subckt nmos$3 a_1300_n36# a_1400_0# a_68_n36# a_344_0# a_872_0# a_1652_n36# a_948_n36#
+ a_244_n36# a_1048_0# sub a_520_0# a_1576_0# a_596_n36# a_1124_n36# a_420_n36# a_1224_0#
+ a_168_0# a_0_0# a_1752_0# a_696_0# a_1476_n36# a_772_n36#
X0 a_1576_0# a_1476_n36# a_1400_0# sub sg13_lv_nmos ad=1.52p pd=8.38u as=1.52p ps=8.38u w=8u l=0.5u
X1 a_1224_0# a_1124_n36# a_1048_0# sub sg13_lv_nmos ad=1.52p pd=8.38u as=1.52p ps=8.38u w=8u l=0.5u
X2 a_872_0# a_772_n36# a_696_0# sub sg13_lv_nmos ad=1.52p pd=8.38u as=1.52p ps=8.38u w=8u l=0.5u
X3 a_520_0# a_420_n36# a_344_0# sub sg13_lv_nmos ad=1.52p pd=8.38u as=1.52p ps=8.38u w=8u l=0.5u
X4 a_696_0# a_596_n36# a_520_0# sub sg13_lv_nmos ad=1.52p pd=8.38u as=1.52p ps=8.38u w=8u l=0.5u
X5 a_168_0# a_68_n36# a_0_0# sub sg13_lv_nmos ad=1.52p pd=8.38u as=2.72p ps=16.68u w=8u l=0.5u
X6 a_1752_0# a_1652_n36# a_1576_0# sub sg13_lv_nmos ad=2.72p pd=16.68u as=1.52p ps=8.38u w=8u l=0.5u
X7 a_344_0# a_244_n36# a_168_0# sub sg13_lv_nmos ad=1.52p pd=8.38u as=1.52p ps=8.38u w=8u l=0.5u
X8 a_1048_0# a_948_n36# a_872_0# sub sg13_lv_nmos ad=1.52p pd=8.38u as=1.52p ps=8.38u w=8u l=0.5u
X9 a_1400_0# a_1300_n36# a_1224_0# sub sg13_lv_nmos ad=1.52p pd=8.38u as=1.52p ps=8.38u w=8u l=0.5u
C0 a_1124_n36# a_1048_0# 0.14923f
C1 a_168_0# a_344_0# 0.20806f
C2 a_1224_0# a_1124_n36# 0.14923f
C3 a_1224_0# a_1400_0# 0.20806f
C4 a_872_0# a_1048_0# 0.20806f
C5 a_420_n36# a_344_0# 0.14923f
C6 a_772_n36# a_696_0# 0.14923f
C7 a_872_0# a_696_0# 0.20806f
C8 a_1476_n36# a_1400_0# 0.14923f
C9 a_168_0# a_68_n36# 0.14923f
C10 a_1576_0# a_1752_0# 0.20806f
C11 a_872_0# a_948_n36# 0.14923f
C12 a_1224_0# a_1300_n36# 0.14923f
C13 a_244_n36# a_168_0# 0.14923f
C14 a_596_n36# a_696_0# 0.14923f
C15 a_0_0# a_168_0# 0.20806f
C16 a_244_n36# a_344_0# 0.14923f
C17 a_420_n36# a_520_0# 0.14923f
C18 a_872_0# a_772_n36# 0.14923f
C19 a_596_n36# a_520_0# 0.14923f
C20 a_520_0# a_344_0# 0.20806f
C21 a_1224_0# a_1048_0# 0.20806f
C22 a_1576_0# a_1476_n36# 0.14923f
C23 a_1400_0# a_1300_n36# 0.14923f
C24 a_1048_0# a_948_n36# 0.14923f
C25 a_0_0# a_68_n36# 0.14923f
C26 a_1652_n36# a_1752_0# 0.14923f
C27 a_1576_0# a_1400_0# 0.20806f
C28 a_1576_0# a_1652_n36# 0.14923f
C29 a_520_0# a_696_0# 0.20806f
C30 a_1752_0# sub 0.53549f
C31 a_1576_0# sub 0.43967f
C32 a_1400_0# sub 0.43465f
C33 a_1224_0# sub 0.43465f
C34 a_1048_0# sub 0.43465f
C35 a_872_0# sub 0.43465f
C36 a_696_0# sub 0.43465f
C37 a_520_0# sub 0.43465f
C38 a_344_0# sub 0.43465f
C39 a_168_0# sub 0.43967f
C40 a_0_0# sub 0.53549f
.ends

.subckt nmos$1 a_1300_n36# a_1400_0# a_68_n36# a_344_0# a_872_0# a_1652_n36# a_948_n36#
+ a_244_n36# a_1048_0# sub a_520_0# a_1576_0# a_596_n36# a_1124_n36# a_420_n36# a_1224_0#
+ a_168_0# a_0_0# a_1752_0# a_696_0# a_1476_n36# a_772_n36#
X0 a_1576_0# a_1476_n36# a_1400_0# sub sg13_lv_nmos ad=0.57p pd=3.38u as=0.57p ps=3.38u w=3u l=0.5u
X1 a_1224_0# a_1124_n36# a_1048_0# sub sg13_lv_nmos ad=0.57p pd=3.38u as=0.57p ps=3.38u w=3u l=0.5u
X2 a_872_0# a_772_n36# a_696_0# sub sg13_lv_nmos ad=0.57p pd=3.38u as=0.57p ps=3.38u w=3u l=0.5u
X3 a_520_0# a_420_n36# a_344_0# sub sg13_lv_nmos ad=0.57p pd=3.38u as=0.57p ps=3.38u w=3u l=0.5u
X4 a_696_0# a_596_n36# a_520_0# sub sg13_lv_nmos ad=0.57p pd=3.38u as=0.57p ps=3.38u w=3u l=0.5u
X5 a_168_0# a_68_n36# a_0_0# sub sg13_lv_nmos ad=0.57p pd=3.38u as=1.02p ps=6.68u w=3u l=0.5u
X6 a_1752_0# a_1652_n36# a_1576_0# sub sg13_lv_nmos ad=1.02p pd=6.68u as=0.57p ps=3.38u w=3u l=0.5u
X7 a_344_0# a_244_n36# a_168_0# sub sg13_lv_nmos ad=0.57p pd=3.38u as=0.57p ps=3.38u w=3u l=0.5u
X8 a_1048_0# a_948_n36# a_872_0# sub sg13_lv_nmos ad=0.57p pd=3.38u as=0.57p ps=3.38u w=3u l=0.5u
X9 a_1400_0# a_1300_n36# a_1224_0# sub sg13_lv_nmos ad=0.57p pd=3.38u as=0.57p ps=3.38u w=3u l=0.5u
C0 a_420_n36# a_520_0# 0.05596f
C1 a_1048_0# a_872_0# 0.07802f
C2 a_1224_0# a_1048_0# 0.07802f
C3 a_520_0# a_344_0# 0.07802f
C4 a_1224_0# a_1300_n36# 0.05596f
C5 a_1124_n36# a_1224_0# 0.05596f
C6 a_344_0# a_168_0# 0.07802f
C7 a_1124_n36# a_1048_0# 0.05596f
C8 a_1224_0# a_1400_0# 0.07802f
C9 a_344_0# a_244_n36# 0.05596f
C10 a_772_n36# a_872_0# 0.05596f
C11 a_0_0# a_168_0# 0.07802f
C12 a_696_0# a_872_0# 0.07802f
C13 a_1476_n36# a_1400_0# 0.05596f
C14 a_1752_0# a_1652_n36# 0.05596f
C15 a_1300_n36# a_1400_0# 0.05596f
C16 a_520_0# a_596_n36# 0.05596f
C17 a_1752_0# a_1576_0# 0.07802f
C18 a_1476_n36# a_1576_0# 0.05596f
C19 a_0_0# a_68_n36# 0.05596f
C20 a_520_0# a_696_0# 0.07802f
C21 a_696_0# a_596_n36# 0.05596f
C22 a_948_n36# a_872_0# 0.05596f
C23 a_420_n36# a_344_0# 0.05596f
C24 a_1576_0# a_1400_0# 0.07802f
C25 a_168_0# a_244_n36# 0.05596f
C26 a_696_0# a_772_n36# 0.05596f
C27 a_948_n36# a_1048_0# 0.05596f
C28 a_1652_n36# a_1576_0# 0.05596f
C29 a_168_0# a_68_n36# 0.05596f
C30 a_1752_0# sub 0.23444f
C31 a_1576_0# sub 0.22109f
C32 a_1400_0# sub 0.21606f
C33 a_1224_0# sub 0.21606f
C34 a_1048_0# sub 0.21606f
C35 a_872_0# sub 0.21606f
C36 a_696_0# sub 0.21606f
C37 a_520_0# sub 0.21606f
C38 a_344_0# sub 0.21606f
C39 a_168_0# sub 0.22109f
C40 a_0_0# sub 0.23444f
.ends

.subckt pmos$5 a_7208_0# a_4392_0# a_2280_0# a_6228_n36# a_5524_n36# a_3412_n36# a_1300_n36#
+ a_6856_0# a_4744_0# a_2632_0# a_4116_n36# a_2708_n36# a_2004_n36# a_7384_0# a_5272_0#
+ a_3512_0# a_3160_0# a_1400_0# a_68_n36# a_7736_0# a_5624_0# a_344_0# a_4040_0# a_6580_n36#
+ w_n62_n62# a_6504_0# a_6152_0# a_7284_n36# a_5876_n36# a_5172_n36# a_3764_n36# a_872_0#
+ a_4468_n36# a_3060_n36# a_1652_n36# a_7812_n36# a_5700_n36# a_2356_n36# a_7032_0#
+ a_6404_n36# a_948_n36# a_6680_0# a_7108_n36# a_244_n36# a_4920_0# a_1048_0# sub
+ a_7912_0# a_7560_0# a_5800_0# a_520_0# a_3688_0# a_1928_0# a_1576_0# a_7460_n36#
+ a_3940_n36# a_6756_n36# a_6052_n36# a_4644_n36# a_2532_n36# a_596_n36# a_4568_0#
+ a_2456_0# a_5348_n36# a_3236_n36# a_1828_n36# a_2808_0# a_1124_n36# a_420_n36# a_5096_0#
+ a_5448_0# a_3336_0# a_1224_0# a_168_0# a_2984_0# a_0_0# a_4216_0# a_2104_0# a_4996_n36#
+ a_6328_0# a_3864_0# a_1752_0# a_4292_n36# a_2884_n36# a_2180_n36# a_5976_0# a_696_0#
+ a_6932_n36# a_3588_n36# a_1476_n36# a_7636_n36# a_4820_n36# a_772_n36#
X0 a_1048_0# a_948_n36# a_872_0# w_n62_n62# sg13_lv_pmos ad=0.57p pd=3.38u as=0.57p ps=3.38u w=3u l=0.5u
X1 a_1400_0# a_1300_n36# a_1224_0# w_n62_n62# sg13_lv_pmos ad=0.57p pd=3.38u as=0.57p ps=3.38u w=3u l=0.5u
X2 a_2808_0# a_2708_n36# a_2632_0# w_n62_n62# sg13_lv_pmos ad=0.57p pd=3.38u as=0.57p ps=3.38u w=3u l=0.5u
X3 a_4216_0# a_4116_n36# a_4040_0# w_n62_n62# sg13_lv_pmos ad=0.57p pd=3.38u as=0.57p ps=3.38u w=3u l=0.5u
X4 a_6328_0# a_6228_n36# a_6152_0# w_n62_n62# sg13_lv_pmos ad=0.57p pd=3.38u as=0.57p ps=3.38u w=3u l=0.5u
X5 a_3512_0# a_3412_n36# a_3336_0# w_n62_n62# sg13_lv_pmos ad=0.57p pd=3.38u as=0.57p ps=3.38u w=3u l=0.5u
X6 a_5624_0# a_5524_n36# a_5448_0# w_n62_n62# sg13_lv_pmos ad=0.57p pd=3.38u as=0.57p ps=3.38u w=3u l=0.5u
X7 a_7736_0# a_7636_n36# a_7560_0# w_n62_n62# sg13_lv_pmos ad=0.57p pd=3.38u as=0.57p ps=3.38u w=3u l=0.5u
X8 a_4920_0# a_4820_n36# a_4744_0# w_n62_n62# sg13_lv_pmos ad=0.57p pd=3.38u as=0.57p ps=3.38u w=3u l=0.5u
X9 a_7032_0# a_6932_n36# a_6856_0# w_n62_n62# sg13_lv_pmos ad=0.57p pd=3.38u as=0.57p ps=3.38u w=3u l=0.5u
X10 a_1576_0# a_1476_n36# a_1400_0# w_n62_n62# sg13_lv_pmos ad=0.57p pd=3.38u as=0.57p ps=3.38u w=3u l=0.5u
X11 a_2280_0# a_2180_n36# a_2104_0# w_n62_n62# sg13_lv_pmos ad=0.57p pd=3.38u as=0.57p ps=3.38u w=3u l=0.5u
X12 a_3688_0# a_3588_n36# a_3512_0# w_n62_n62# sg13_lv_pmos ad=0.57p pd=3.38u as=0.57p ps=3.38u w=3u l=0.5u
X13 a_2984_0# a_2884_n36# a_2808_0# w_n62_n62# sg13_lv_pmos ad=0.57p pd=3.38u as=0.57p ps=3.38u w=3u l=0.5u
X14 a_4392_0# a_4292_n36# a_4216_0# w_n62_n62# sg13_lv_pmos ad=0.57p pd=3.38u as=0.57p ps=3.38u w=3u l=0.5u
X15 a_5096_0# a_4996_n36# a_4920_0# w_n62_n62# sg13_lv_pmos ad=0.57p pd=3.38u as=0.57p ps=3.38u w=3u l=0.5u
X16 a_1224_0# a_1124_n36# a_1048_0# w_n62_n62# sg13_lv_pmos ad=0.57p pd=3.38u as=0.57p ps=3.38u w=3u l=0.5u
X17 a_1928_0# a_1828_n36# a_1752_0# w_n62_n62# sg13_lv_pmos ad=0.57p pd=3.38u as=0.57p ps=3.38u w=3u l=0.5u
X18 a_3336_0# a_3236_n36# a_3160_0# w_n62_n62# sg13_lv_pmos ad=0.57p pd=3.38u as=0.57p ps=3.38u w=3u l=0.5u
X19 a_872_0# a_772_n36# a_696_0# w_n62_n62# sg13_lv_pmos ad=0.57p pd=3.38u as=0.57p ps=3.38u w=3u l=0.5u
X20 a_2632_0# a_2532_n36# a_2456_0# w_n62_n62# sg13_lv_pmos ad=0.57p pd=3.38u as=0.57p ps=3.38u w=3u l=0.5u
X21 a_5448_0# a_5348_n36# a_5272_0# w_n62_n62# sg13_lv_pmos ad=0.57p pd=3.38u as=0.57p ps=3.38u w=3u l=0.5u
X22 a_4040_0# a_3940_n36# a_3864_0# w_n62_n62# sg13_lv_pmos ad=0.57p pd=3.38u as=0.57p ps=3.38u w=3u l=0.5u
X23 a_4744_0# a_4644_n36# a_4568_0# w_n62_n62# sg13_lv_pmos ad=0.57p pd=3.38u as=0.57p ps=3.38u w=3u l=0.5u
X24 a_6152_0# a_6052_n36# a_5976_0# w_n62_n62# sg13_lv_pmos ad=0.57p pd=3.38u as=0.57p ps=3.38u w=3u l=0.5u
X25 a_6856_0# a_6756_n36# a_6680_0# w_n62_n62# sg13_lv_pmos ad=0.57p pd=3.38u as=0.57p ps=3.38u w=3u l=0.5u
X26 a_7560_0# a_7460_n36# a_7384_0# w_n62_n62# sg13_lv_pmos ad=0.57p pd=3.38u as=0.57p ps=3.38u w=3u l=0.5u
X27 a_520_0# a_420_n36# a_344_0# w_n62_n62# sg13_lv_pmos ad=0.57p pd=3.38u as=0.57p ps=3.38u w=3u l=0.5u
X28 a_6504_0# a_6404_n36# a_6328_0# w_n62_n62# sg13_lv_pmos ad=0.57p pd=3.38u as=0.57p ps=3.38u w=3u l=0.5u
X29 a_7208_0# a_7108_n36# a_7032_0# w_n62_n62# sg13_lv_pmos ad=0.57p pd=3.38u as=0.57p ps=3.38u w=3u l=0.5u
X30 a_5800_0# a_5700_n36# a_5624_0# w_n62_n62# sg13_lv_pmos ad=0.57p pd=3.38u as=0.57p ps=3.38u w=3u l=0.5u
X31 a_696_0# a_596_n36# a_520_0# w_n62_n62# sg13_lv_pmos ad=0.57p pd=3.38u as=0.57p ps=3.38u w=3u l=0.5u
X32 a_2456_0# a_2356_n36# a_2280_0# w_n62_n62# sg13_lv_pmos ad=0.57p pd=3.38u as=0.57p ps=3.38u w=3u l=0.5u
X33 a_4568_0# a_4468_n36# a_4392_0# w_n62_n62# sg13_lv_pmos ad=0.57p pd=3.38u as=0.57p ps=3.38u w=3u l=0.5u
X34 a_7912_0# a_7812_n36# a_7736_0# w_n62_n62# sg13_lv_pmos ad=1.02p pd=6.68u as=0.57p ps=3.38u w=3u l=0.5u
X35 a_168_0# a_68_n36# a_0_0# w_n62_n62# sg13_lv_pmos ad=0.57p pd=3.38u as=1.02p ps=6.68u w=3u l=0.5u
X36 a_1752_0# a_1652_n36# a_1576_0# w_n62_n62# sg13_lv_pmos ad=0.57p pd=3.38u as=0.57p ps=3.38u w=3u l=0.5u
X37 a_3160_0# a_3060_n36# a_2984_0# w_n62_n62# sg13_lv_pmos ad=0.57p pd=3.38u as=0.57p ps=3.38u w=3u l=0.5u
X38 a_3864_0# a_3764_n36# a_3688_0# w_n62_n62# sg13_lv_pmos ad=0.57p pd=3.38u as=0.57p ps=3.38u w=3u l=0.5u
X39 a_5272_0# a_5172_n36# a_5096_0# w_n62_n62# sg13_lv_pmos ad=0.57p pd=3.38u as=0.57p ps=3.38u w=3u l=0.5u
X40 a_5976_0# a_5876_n36# a_5800_0# w_n62_n62# sg13_lv_pmos ad=0.57p pd=3.38u as=0.57p ps=3.38u w=3u l=0.5u
X41 a_6680_0# a_6580_n36# a_6504_0# w_n62_n62# sg13_lv_pmos ad=0.57p pd=3.38u as=0.57p ps=3.38u w=3u l=0.5u
X42 a_7384_0# a_7284_n36# a_7208_0# w_n62_n62# sg13_lv_pmos ad=0.57p pd=3.38u as=0.57p ps=3.38u w=3u l=0.5u
X43 a_344_0# a_244_n36# a_168_0# w_n62_n62# sg13_lv_pmos ad=0.57p pd=3.38u as=0.57p ps=3.38u w=3u l=0.5u
X44 a_2104_0# a_2004_n36# a_1928_0# w_n62_n62# sg13_lv_pmos ad=0.57p pd=3.38u as=0.57p ps=3.38u w=3u l=0.5u
C0 a_2104_0# a_2280_0# 0.07802f
C1 a_2180_n36# a_2104_0# 0.05596f
C2 a_4216_0# a_4392_0# 0.07802f
C3 w_n62_n62# a_872_0# 0.03185f
C4 w_n62_n62# a_5700_n36# 0.1652f
C5 w_n62_n62# a_6328_0# 0.03185f
C6 a_1752_0# a_1652_n36# 0.05596f
C7 a_7384_0# a_7208_0# 0.07802f
C8 a_772_n36# a_872_0# 0.05596f
C9 w_n62_n62# a_1400_0# 0.03185f
C10 a_5524_n36# a_5624_0# 0.05596f
C11 a_2808_0# a_2984_0# 0.07802f
C12 a_244_n36# a_344_0# 0.05596f
C13 a_5448_0# a_5348_n36# 0.05596f
C14 a_6328_0# a_6504_0# 0.07802f
C15 a_7108_n36# a_7032_0# 0.05596f
C16 w_n62_n62# a_7032_0# 0.03185f
C17 a_5272_0# a_5096_0# 0.07802f
C18 a_696_0# a_596_n36# 0.05596f
C19 w_n62_n62# a_3864_0# 0.03185f
C20 w_n62_n62# a_2456_0# 0.03185f
C21 a_7384_0# a_7284_n36# 0.05596f
C22 a_1400_0# a_1476_n36# 0.05596f
C23 a_0_0# a_68_n36# 0.05596f
C24 a_6052_n36# a_5976_0# 0.05596f
C25 a_6228_n36# w_n62_n62# 0.1652f
C26 a_5700_n36# a_5624_0# 0.05596f
C27 w_n62_n62# a_1652_n36# 0.1652f
C28 w_n62_n62# a_3764_n36# 0.1652f
C29 a_3336_0# a_3412_n36# 0.05596f
C30 a_6580_n36# a_6680_0# 0.05596f
C31 w_n62_n62# a_1300_n36# 0.1652f
C32 a_2180_n36# w_n62_n62# 0.1652f
C33 w_n62_n62# a_2280_0# 0.03185f
C34 a_1400_0# a_1224_0# 0.07802f
C35 a_7736_0# a_7912_0# 0.07802f
C36 a_2808_0# a_2708_n36# 0.05596f
C37 w_n62_n62# a_4040_0# 0.03185f
C38 w_n62_n62# a_696_0# 0.03185f
C39 a_5448_0# w_n62_n62# 0.03185f
C40 a_2356_n36# a_2456_0# 0.05596f
C41 a_1752_0# a_1576_0# 0.07802f
C42 w_n62_n62# a_6052_n36# 0.1652f
C43 w_n62_n62# a_168_0# 0.03185f
C44 a_2456_0# a_2632_0# 0.07802f
C45 a_5800_0# a_5876_n36# 0.05596f
C46 a_4216_0# a_4292_n36# 0.05596f
C47 a_4392_0# a_4468_n36# 0.05596f
C48 a_3688_0# a_3864_0# 0.07802f
C49 a_772_n36# a_696_0# 0.05596f
C50 a_7636_n36# a_7560_0# 0.05596f
C51 a_4744_0# a_4820_n36# 0.05596f
C52 a_3236_n36# w_n62_n62# 0.1652f
C53 w_n62_n62# a_7636_n36# 0.1652f
C54 w_n62_n62# a_6580_n36# 0.1652f
C55 a_520_0# a_596_n36# 0.05596f
C56 a_4216_0# a_4116_n36# 0.05596f
C57 a_2356_n36# a_2280_0# 0.05596f
C58 a_5800_0# a_5976_0# 0.07802f
C59 a_1752_0# a_1828_n36# 0.05596f
C60 w_n62_n62# a_4392_0# 0.03185f
C61 a_7384_0# a_7560_0# 0.07802f
C62 a_3688_0# a_3764_n36# 0.05596f
C63 a_5448_0# a_5524_n36# 0.05596f
C64 w_n62_n62# a_3336_0# 0.03185f
C65 a_6152_0# a_5976_0# 0.07802f
C66 w_n62_n62# a_7384_0# 0.03185f
C67 a_4744_0# w_n62_n62# 0.03185f
C68 a_6856_0# a_6680_0# 0.07802f
C69 a_3160_0# a_3060_n36# 0.05596f
C70 a_1300_n36# a_1224_0# 0.05596f
C71 w_n62_n62# a_2532_n36# 0.1652f
C72 a_6228_n36# a_6328_0# 0.05596f
C73 a_4568_0# a_4468_n36# 0.05596f
C74 a_6580_n36# a_6504_0# 0.05596f
C75 w_n62_n62# a_3160_0# 0.03185f
C76 w_n62_n62# a_6932_n36# 0.1652f
C77 a_3512_0# a_3412_n36# 0.05596f
C78 a_1928_0# a_1828_n36# 0.05596f
C79 a_5448_0# a_5624_0# 0.07802f
C80 w_n62_n62# a_1576_0# 0.03185f
C81 a_2984_0# a_3060_n36# 0.05596f
C82 a_4920_0# a_4744_0# 0.07802f
C83 w_n62_n62# a_5800_0# 0.03185f
C84 a_5448_0# a_5272_0# 0.07802f
C85 a_7208_0# a_7284_n36# 0.05596f
C86 a_6404_n36# w_n62_n62# 0.1652f
C87 w_n62_n62# a_2984_0# 0.03185f
C88 a_4568_0# w_n62_n62# 0.03185f
C89 w_n62_n62# a_6152_0# 0.03185f
C90 a_696_0# a_872_0# 0.07802f
C91 a_1400_0# a_1300_n36# 0.05596f
C92 w_n62_n62# a_344_0# 0.03185f
C93 w_n62_n62# a_520_0# 0.03185f
C94 w_n62_n62# a_68_n36# 0.16788f
C95 w_n62_n62# a_420_n36# 0.1652f
C96 a_948_n36# a_1048_0# 0.05596f
C97 a_7384_0# a_7460_n36# 0.05596f
C98 w_n62_n62# a_1828_n36# 0.1652f
C99 a_6856_0# w_n62_n62# 0.03185f
C100 a_6404_n36# a_6504_0# 0.05596f
C101 a_1476_n36# a_1576_0# 0.05596f
C102 a_3764_n36# a_3864_0# 0.05596f
C103 a_3512_0# a_3588_n36# 0.05596f
C104 w_n62_n62# a_4644_n36# 0.1652f
C105 a_7736_0# a_7812_n36# 0.05596f
C106 a_2532_n36# a_2632_0# 0.05596f
C107 a_2456_0# a_2280_0# 0.07802f
C108 a_7736_0# a_7560_0# 0.07802f
C109 a_1048_0# a_1124_n36# 0.05596f
C110 w_n62_n62# a_948_n36# 0.1652f
C111 a_3512_0# w_n62_n62# 0.03185f
C112 w_n62_n62# a_7736_0# 0.03185f
C113 a_4040_0# a_3864_0# 0.07802f
C114 a_5800_0# a_5624_0# 0.07802f
C115 w_n62_n62# a_1124_n36# 0.1652f
C116 a_2984_0# a_2884_n36# 0.05596f
C117 w_n62_n62# a_244_n36# 0.1652f
C118 w_n62_n62# a_2708_n36# 0.1652f
C119 w_n62_n62# a_4292_n36# 0.1652f
C120 a_6856_0# a_6756_n36# 0.05596f
C121 a_2180_n36# a_2280_0# 0.05596f
C122 a_7812_n36# a_7912_0# 0.05596f
C123 w_n62_n62# a_2808_0# 0.03185f
C124 a_5800_0# a_5700_n36# 0.05596f
C125 a_6404_n36# a_6328_0# 0.05596f
C126 a_1400_0# a_1576_0# 0.07802f
C127 a_7108_n36# a_7208_0# 0.05596f
C128 w_n62_n62# a_7912_0# 0.03433f
C129 w_n62_n62# a_4216_0# 0.03185f
C130 a_6152_0# a_6328_0# 0.07802f
C131 w_n62_n62# a_7208_0# 0.03185f
C132 w_n62_n62# a_4116_n36# 0.1652f
C133 w_n62_n62# a_0_0# 0.03433f
C134 a_6932_n36# a_7032_0# 0.05596f
C135 a_1928_0# a_2104_0# 0.07802f
C136 a_2532_n36# a_2456_0# 0.05596f
C137 a_3512_0# a_3688_0# 0.07802f
C138 a_3940_n36# w_n62_n62# 0.1652f
C139 a_948_n36# a_872_0# 0.05596f
C140 a_5976_0# a_5876_n36# 0.05596f
C141 a_2708_n36# a_2632_0# 0.05596f
C142 a_1752_0# a_1928_0# 0.07802f
C143 a_1124_n36# a_1224_0# 0.05596f
C144 a_2808_0# a_2632_0# 0.07802f
C145 w_n62_n62# a_7284_n36# 0.1652f
C146 a_1652_n36# a_1576_0# 0.05596f
C147 a_2808_0# a_2884_n36# 0.05596f
C148 w_n62_n62# a_2104_0# 0.03185f
C149 a_6856_0# a_7032_0# 0.07802f
C150 a_6228_n36# a_6152_0# 0.05596f
C151 w_n62_n62# a_5172_n36# 0.1652f
C152 w_n62_n62# a_5348_n36# 0.1652f
C153 w_n62_n62# a_3412_n36# 0.1652f
C154 w_n62_n62# a_5876_n36# 0.1652f
C155 w_n62_n62# a_1752_0# 0.03185f
C156 a_3236_n36# a_3336_0# 0.05596f
C157 w_n62_n62# a_596_n36# 0.1652f
C158 w_n62_n62# a_6680_0# 0.03185f
C159 a_3236_n36# a_3160_0# 0.05596f
C160 a_6152_0# a_6052_n36# 0.05596f
C161 a_520_0# a_696_0# 0.07802f
C162 w_n62_n62# a_5976_0# 0.03185f
C163 w_n62_n62# a_1928_0# 0.03185f
C164 a_168_0# a_344_0# 0.07802f
C165 w_n62_n62# a_4820_n36# 0.1652f
C166 a_3336_0# a_3160_0# 0.07802f
C167 a_6680_0# a_6504_0# 0.07802f
C168 a_2004_n36# a_2104_0# 0.05596f
C169 a_168_0# a_68_n36# 0.05596f
C170 w_n62_n62# a_4468_n36# 0.1652f
C171 w_n62_n62# a_1048_0# 0.03185f
C172 a_5096_0# a_5172_n36# 0.05596f
C173 w_n62_n62# a_7812_n36# 0.16788f
C174 a_7208_0# a_7032_0# 0.07802f
C175 w_n62_n62# a_3588_n36# 0.1652f
C176 a_4568_0# a_4392_0# 0.07802f
C177 w_n62_n62# a_7560_0# 0.03185f
C178 w_n62_n62# a_3060_n36# 0.1652f
C179 a_4920_0# a_4820_n36# 0.05596f
C180 a_6680_0# a_6756_n36# 0.05596f
C181 a_7108_n36# w_n62_n62# 0.1652f
C182 a_4996_n36# w_n62_n62# 0.1652f
C183 a_4568_0# a_4744_0# 0.07802f
C184 a_5272_0# a_5172_n36# 0.05596f
C185 a_5272_0# a_5348_n36# 0.05596f
C186 a_2984_0# a_3160_0# 0.07802f
C187 w_n62_n62# a_772_n36# 0.1652f
C188 a_3940_n36# a_3864_0# 0.05596f
C189 a_4920_0# a_4996_n36# 0.05596f
C190 a_2004_n36# a_1928_0# 0.05596f
C191 w_n62_n62# a_6504_0# 0.03185f
C192 a_4920_0# w_n62_n62# 0.03185f
C193 a_168_0# a_244_n36# 0.05596f
C194 a_7736_0# a_7636_n36# 0.05596f
C195 a_4744_0# a_4644_n36# 0.05596f
C196 a_6856_0# a_6932_n36# 0.05596f
C197 w_n62_n62# a_1476_n36# 0.1652f
C198 a_4216_0# a_4040_0# 0.07802f
C199 a_3512_0# a_3336_0# 0.07802f
C200 w_n62_n62# a_5524_n36# 0.1652f
C201 a_7560_0# a_7460_n36# 0.05596f
C202 a_4040_0# a_4116_n36# 0.05596f
C203 a_344_0# a_520_0# 0.07802f
C204 a_4996_n36# a_5096_0# 0.05596f
C205 w_n62_n62# a_6756_n36# 0.1652f
C206 a_1048_0# a_1224_0# 0.07802f
C207 w_n62_n62# a_5096_0# 0.03185f
C208 w_n62_n62# a_2356_n36# 0.1652f
C209 a_3588_n36# a_3688_0# 0.05596f
C210 w_n62_n62# a_7460_n36# 0.1652f
C211 a_420_n36# a_344_0# 0.05596f
C212 a_420_n36# a_520_0# 0.05596f
C213 w_n62_n62# a_2632_0# 0.03185f
C214 a_1048_0# a_872_0# 0.07802f
C215 a_2004_n36# w_n62_n62# 0.1652f
C216 a_4292_n36# a_4392_0# 0.05596f
C217 a_0_0# a_168_0# 0.07802f
C218 w_n62_n62# a_5624_0# 0.03185f
C219 a_4568_0# a_4644_n36# 0.05596f
C220 a_3940_n36# a_4040_0# 0.05596f
C221 w_n62_n62# a_3688_0# 0.03185f
C222 w_n62_n62# a_2884_n36# 0.1652f
C223 w_n62_n62# a_1224_0# 0.03185f
C224 a_4920_0# a_5096_0# 0.07802f
C225 w_n62_n62# a_5272_0# 0.03185f
C226 a_7912_0# sub 0.13282f
C227 a_7736_0# sub 0.05283f
C228 a_7560_0# sub 0.04914f
C229 a_7384_0# sub 0.04914f
C230 a_7208_0# sub 0.04914f
C231 a_7032_0# sub 0.04914f
C232 a_6856_0# sub 0.04914f
C233 a_6680_0# sub 0.04914f
C234 a_6504_0# sub 0.04914f
C235 a_6328_0# sub 0.04914f
C236 a_6152_0# sub 0.04914f
C237 a_5976_0# sub 0.04914f
C238 a_5800_0# sub 0.04914f
C239 a_5624_0# sub 0.04914f
C240 a_5448_0# sub 0.04914f
C241 a_5272_0# sub 0.04914f
C242 a_5096_0# sub 0.04914f
C243 a_4920_0# sub 0.04914f
C244 a_4744_0# sub 0.04914f
C245 a_4568_0# sub 0.04914f
C246 a_4392_0# sub 0.04914f
C247 a_4216_0# sub 0.04914f
C248 a_4040_0# sub 0.04914f
C249 a_3864_0# sub 0.04914f
C250 a_3688_0# sub 0.04914f
C251 a_3512_0# sub 0.04914f
C252 a_3336_0# sub 0.04914f
C253 a_3160_0# sub 0.04914f
C254 a_2984_0# sub 0.04914f
C255 a_2808_0# sub 0.04914f
C256 a_2632_0# sub 0.04914f
C257 a_2456_0# sub 0.04914f
C258 a_2280_0# sub 0.04914f
C259 a_2104_0# sub 0.04914f
C260 a_1928_0# sub 0.04914f
C261 a_1752_0# sub 0.04914f
C262 a_1576_0# sub 0.04914f
C263 a_1400_0# sub 0.04914f
C264 a_1224_0# sub 0.04914f
C265 a_1048_0# sub 0.04914f
C266 a_872_0# sub 0.04914f
C267 a_696_0# sub 0.04914f
C268 a_520_0# sub 0.04914f
C269 a_344_0# sub 0.04914f
C270 a_168_0# sub 0.05283f
C271 a_0_0# sub 0.13282f
.ends

.subckt nmos$6 a_68_n36# a_188_0# sub a_0_0#
X0 a_188_0# a_68_n36# a_0_0# sub sg13_lv_nmos ad=1.02p pd=6.68u as=1.02p ps=6.68u w=3u l=0.6u
C0 a_68_n36# a_0_0# 0.06311f
C1 a_188_0# a_0_0# 0.06819f
C2 a_68_n36# a_188_0# 0.06311f
C3 a_188_0# sub 0.25861f
C4 a_0_0# sub 0.25861f
.ends

.subckt nmos$4 a_68_n36# sub a_168_0# a_0_0#
X0 a_168_0# a_68_n36# a_0_0# sub sg13_lv_nmos ad=2.72p pd=16.68u as=2.72p ps=16.68u w=8u l=0.5u
C0 a_68_n36# a_0_0# 0.14923f
C1 a_168_0# a_0_0# 0.20806f
C2 a_68_n36# a_168_0# 0.14923f
C3 a_168_0# sub 0.54051f
C4 a_0_0# sub 0.54051f
.ends

.subckt CASCODE_Block V_ON2 V_OP2 V_ON1 V_OP1 V_IN V_IP V_BIAS1 VSS V_BIAS4 V_BIAS3
+ VCMFBG VDD V_BIAS2
Xpmos_8 V_BIAS1 V_BIAS1 V_BIAS1 VDD V_BIAS1 VDD V_BIAS1 V_BIAS1 VDD VDD V_BIAS1 m1_771_n260#
+ m1_771_n260# V_BIAS1 m1_771_n260# V_BIAS1 V_BIAS1 VSS VDD m1_771_n260# m1_771_n260#
+ V_BIAS1 VDD VDD V_BIAS1 m1_771_n260# V_BIAS1 VDD V_BIAS1 V_BIAS1 V_BIAS1 VDD V_BIAS1
+ m1_771_n260# m1_771_n260# VDD VDD V_BIAS1 V_BIAS1 VDD V_BIAS1 m1_771_n260# m1_771_n260#
+ pmos
Xnmos$2_3 VCMFBG VCMFBG VSS m1_n3675_n5760# VSS VSS VCMFBG VSS m1_n3675_n5760# VCMFBG
+ m1_n3675_n5760# VCMFBG nmos$2
Xpmos_9 V_BIAS1 V_BIAS1 V_BIAS1 VDD V_BIAS1 VDD V_BIAS1 V_BIAS1 VDD VDD V_BIAS1 m1_771_n260#
+ m1_771_n260# V_BIAS1 m1_771_n260# V_BIAS1 V_BIAS1 VSS VDD m1_771_n260# m1_771_n260#
+ V_BIAS1 VDD VDD V_BIAS1 m1_771_n260# V_BIAS1 VDD V_BIAS1 V_BIAS1 V_BIAS1 VDD V_BIAS1
+ m1_771_n260# m1_771_n260# VDD VDD V_BIAS1 V_BIAS1 VDD V_BIAS1 m1_771_n260# m1_771_n260#
+ pmos
Xpmos$6_0 V_OP2 V_OP1 V_OP1 V_OP2 V_OP1 V_OP1 VDD VDD VDD V_OP1 VDD VDD V_OP2 V_OP1
+ V_OP1 V_OP1 V_OP1 V_OP1 VDD VSS V_OP2 V_OP2 V_OP2 V_OP1 V_OP1 VDD V_OP1 V_OP1 VDD
+ V_OP1 V_OP1 V_OP2 V_OP2 V_OP2 V_OP2 VDD VDD VDD V_OP1 V_OP1 VDD V_OP1 V_OP1 pmos$6
Xpmos$6_1 V_OP2 V_OP1 V_OP1 V_OP2 V_OP1 V_OP1 VDD VDD VDD V_OP1 VDD VDD V_OP2 V_OP1
+ V_OP1 V_OP1 V_OP1 V_OP1 VDD VSS V_OP2 V_OP2 V_OP2 V_OP1 V_OP1 VDD V_OP1 V_OP1 VDD
+ V_OP1 V_OP1 V_OP2 V_OP2 V_OP2 V_OP2 VDD VDD VDD V_OP1 V_OP1 VDD V_OP1 V_OP1 pmos$6
Xpmos$6_3 V_ON2 V_ON1 V_ON1 V_ON2 V_ON1 V_ON1 VDD VDD VDD V_ON1 VDD VDD V_ON2 V_ON1
+ V_ON1 V_ON1 V_ON1 V_ON1 VDD VSS V_ON2 V_ON2 V_ON2 V_ON1 V_ON1 VDD V_ON1 V_ON1 VDD
+ V_ON1 V_ON1 V_ON2 V_ON2 V_ON2 V_ON2 VDD VDD VDD V_ON1 V_ON1 VDD V_ON1 V_ON1 pmos$6
Xpmos$6_2 V_ON2 V_ON1 V_ON1 V_ON2 V_ON1 V_ON1 VDD VDD VDD V_ON1 VDD VDD V_ON2 V_ON1
+ V_ON1 V_ON1 V_ON1 V_ON1 VDD VSS V_ON2 V_ON2 V_ON2 V_ON1 V_ON1 VDD V_ON1 V_ON1 VDD
+ V_ON1 V_ON1 V_ON2 V_ON2 V_ON2 V_ON2 VDD VDD VDD V_ON1 V_ON1 VDD V_ON1 V_ON1 pmos$6
Xcmim$1_0 VSS m1_11721_n5608# V_OP2 cmim$1
Xpmos$4_0 VDD VDD VSS VDD VDD pmos$4
Xpmos$4_1 VDD VDD VSS VDD VDD pmos$4
Xpmos$4_2 VDD VDD VSS VDD VDD pmos$4
Xcmim$1_1 VSS m1_n8092_n5681# V_ON2 cmim$1
Xpmos$2_0 VDD VDD VSS VDD VDD pmos$2
Xpmos$4_3 VDD VDD VSS VDD VDD pmos$4
Xpmos$4_4 VDD VDD VSS VDD VDD pmos$4
Xnmos$5_0 VSS VSS VSS VSS nmos$5
Xpmos$2_1 VDD VDD VSS VDD VDD pmos$2
Xpmos$2_2 VDD VDD VSS VDD VDD pmos$2
Xpmos$4_5 VDD VDD VSS VDD VDD pmos$4
Xnmos$5_1 VSS VSS VSS VSS nmos$5
Xrppd$1_0 VSS V_OP1 m1_11721_n5608# rppd$1
Xnmos$5_3 VSS VSS VSS VSS nmos$5
Xnmos$5_2 VSS VSS VSS VSS nmos$5
Xpmos$2_3 VDD VDD VSS VDD VDD pmos$2
Xpmos$4_6 VDD VDD VSS VDD VDD pmos$4
Xnmos$3_0 V_BIAS4 VSS V_BIAS4 VSS V_OP2 V_BIAS4 V_BIAS4 V_BIAS4 VSS VSS V_OP2 V_OP2
+ V_BIAS4 V_BIAS4 V_BIAS4 V_OP2 V_OP2 VSS VSS VSS V_BIAS4 V_BIAS4 nmos$3
Xpmos$2_4 VDD VDD VSS VDD VDD pmos$2
Xpmos$4_7 VDD VDD VSS VDD VDD pmos$4
Xrppd$1_1 VSS V_ON1 m1_n8092_n5681# rppd$1
Xnmos$3_1 V_BIAS4 VSS V_BIAS4 VSS V_ON2 V_BIAS4 V_BIAS4 V_BIAS4 VSS VSS V_ON2 V_ON2
+ V_BIAS4 V_BIAS4 V_BIAS4 V_ON2 V_ON2 VSS VSS VSS V_BIAS4 V_BIAS4 nmos$3
Xpmos$2_5 VDD VDD VSS VDD VDD pmos$2
Xnmos$1_0 V_BIAS3 m1_1068_n5836# V_BIAS3 m1_1068_n5836# V_OP1 V_BIAS3 V_BIAS3 V_BIAS3
+ m1_1068_n5836# VSS V_OP1 V_OP1 V_BIAS3 V_BIAS3 V_BIAS3 V_OP1 V_OP1 m1_1068_n5836#
+ m1_1068_n5836# m1_1068_n5836# V_BIAS3 V_BIAS3 nmos$1
Xpmos$2_6 VDD VDD VSS VDD VDD pmos$2
Xpmos$2_7 VDD VDD VSS VDD VDD pmos$2
Xnmos$1_1 V_BIAS3 m1_n3675_n5760# V_BIAS3 m1_n3675_n5760# V_ON1 V_BIAS3 V_BIAS3 V_BIAS3
+ m1_n3675_n5760# VSS V_ON1 V_ON1 V_BIAS3 V_BIAS3 V_BIAS3 V_ON1 V_ON1 m1_n3675_n5760#
+ m1_n3675_n5760# m1_n3675_n5760# V_BIAS3 V_BIAS3 nmos$1
Xpmos$5_0 V_OP1 V_OP1 V_OP1 V_BIAS2 V_BIAS2 V_BIAS2 V_BIAS2 V_OP1 V_OP1 V_OP1 V_BIAS2
+ V_BIAS2 V_BIAS2 m1_n4711_n3022# m1_n4711_n3022# m1_n4711_n3022# m1_n4711_n3022#
+ m1_n4711_n3022# V_BIAS2 m1_n4711_n3022# m1_n4711_n3022# m1_n4711_n3022# V_OP1 V_BIAS2
+ VDD V_OP1 V_OP1 V_BIAS2 V_BIAS2 V_BIAS2 V_BIAS2 V_OP1 V_BIAS2 V_BIAS2 V_BIAS2 V_BIAS2
+ V_BIAS2 V_BIAS2 m1_n4711_n3022# V_BIAS2 V_BIAS2 m1_n4711_n3022# V_BIAS2 V_BIAS2
+ m1_n4711_n3022# m1_n4711_n3022# VSS V_OP1 V_OP1 V_OP1 V_OP1 V_OP1 V_OP1 V_OP1 V_BIAS2
+ V_BIAS2 V_BIAS2 V_BIAS2 V_BIAS2 V_BIAS2 V_BIAS2 m1_n4711_n3022# m1_n4711_n3022#
+ V_BIAS2 V_BIAS2 V_BIAS2 m1_n4711_n3022# V_BIAS2 V_BIAS2 V_OP1 V_OP1 V_OP1 V_OP1
+ V_OP1 V_OP1 m1_n4711_n3022# m1_n4711_n3022# m1_n4711_n3022# V_BIAS2 m1_n4711_n3022#
+ m1_n4711_n3022# m1_n4711_n3022# V_BIAS2 V_BIAS2 V_BIAS2 m1_n4711_n3022# m1_n4711_n3022#
+ V_BIAS2 V_BIAS2 V_BIAS2 V_BIAS2 V_BIAS2 V_BIAS2 pmos$5
Xpmos$5_1 V_ON1 V_ON1 V_ON1 V_BIAS2 V_BIAS2 V_BIAS2 V_BIAS2 V_ON1 V_ON1 V_ON1 V_BIAS2
+ V_BIAS2 V_BIAS2 m1_n6873_n3119# m1_n6873_n3119# m1_n6873_n3119# m1_n6873_n3119#
+ m1_n6873_n3119# V_BIAS2 m1_n6873_n3119# m1_n6873_n3119# m1_n6873_n3119# V_ON1 V_BIAS2
+ VDD V_ON1 V_ON1 V_BIAS2 V_BIAS2 V_BIAS2 V_BIAS2 V_ON1 V_BIAS2 V_BIAS2 V_BIAS2 V_BIAS2
+ V_BIAS2 V_BIAS2 m1_n6873_n3119# V_BIAS2 V_BIAS2 m1_n6873_n3119# V_BIAS2 V_BIAS2
+ m1_n6873_n3119# m1_n6873_n3119# VSS V_ON1 V_ON1 V_ON1 V_ON1 V_ON1 V_ON1 V_ON1 V_BIAS2
+ V_BIAS2 V_BIAS2 V_BIAS2 V_BIAS2 V_BIAS2 V_BIAS2 m1_n6873_n3119# m1_n6873_n3119#
+ V_BIAS2 V_BIAS2 V_BIAS2 m1_n6873_n3119# V_BIAS2 V_BIAS2 V_ON1 V_ON1 V_ON1 V_ON1
+ V_ON1 V_ON1 m1_n6873_n3119# m1_n6873_n3119# m1_n6873_n3119# V_BIAS2 m1_n6873_n3119#
+ m1_n6873_n3119# m1_n6873_n3119# V_BIAS2 V_BIAS2 V_BIAS2 m1_n6873_n3119# m1_n6873_n3119#
+ V_BIAS2 V_BIAS2 V_BIAS2 V_BIAS2 V_BIAS2 V_BIAS2 pmos$5
Xnmos$6_0 VSS VSS VSS VSS nmos$6
Xnmos$6_1 VSS VSS VSS VSS nmos$6
Xpmos_0 V_IN V_IN V_IN m1_771_n260# V_IN m1_771_n260# V_IN V_IN VDD m1_771_n260# V_IN
+ m1_n6873_n3119# m1_n6873_n3119# V_IN m1_n6873_n3119# V_IN V_IN VSS m1_771_n260#
+ m1_n6873_n3119# m1_n6873_n3119# V_IN m1_771_n260# m1_771_n260# V_IN m1_n6873_n3119#
+ V_IN m1_771_n260# V_IN V_IN V_IN m1_771_n260# V_IN m1_n6873_n3119# m1_n6873_n3119#
+ m1_771_n260# m1_771_n260# V_IN V_IN m1_771_n260# V_IN m1_n6873_n3119# m1_n6873_n3119#
+ pmos
Xpmos_1 V_IP V_IP V_IP m1_771_n260# V_IP m1_771_n260# V_IP V_IP VDD m1_771_n260# V_IP
+ m1_n4711_n3022# m1_n4711_n3022# V_IP m1_n4711_n3022# V_IP V_IP VSS m1_771_n260#
+ m1_n4711_n3022# m1_n4711_n3022# V_IP m1_771_n260# m1_771_n260# V_IP m1_n4711_n3022#
+ V_IP m1_771_n260# V_IP V_IP V_IP m1_771_n260# V_IP m1_n4711_n3022# m1_n4711_n3022#
+ m1_771_n260# m1_771_n260# V_IP V_IP m1_771_n260# V_IP m1_n4711_n3022# m1_n4711_n3022#
+ pmos
Xnmos$4_0 VSS VSS VSS VSS nmos$4
Xpmos_2 V_IN V_IN V_IN m1_771_n260# V_IN m1_771_n260# V_IN V_IN VDD m1_771_n260# V_IN
+ m1_n6873_n3119# m1_n6873_n3119# V_IN m1_n6873_n3119# V_IN V_IN VSS m1_771_n260#
+ m1_n6873_n3119# m1_n6873_n3119# V_IN m1_771_n260# m1_771_n260# V_IN m1_n6873_n3119#
+ V_IN m1_771_n260# V_IN V_IN V_IN m1_771_n260# V_IN m1_n6873_n3119# m1_n6873_n3119#
+ m1_771_n260# m1_771_n260# V_IN V_IN m1_771_n260# V_IN m1_n6873_n3119# m1_n6873_n3119#
+ pmos
Xnmos$4_1 VSS VSS VSS VSS nmos$4
Xnmos$4_2 VSS VSS VSS VSS nmos$4
Xpmos_3 V_IP V_IP V_IP m1_771_n260# V_IP m1_771_n260# V_IP V_IP VDD m1_771_n260# V_IP
+ m1_n4711_n3022# m1_n4711_n3022# V_IP m1_n4711_n3022# V_IP V_IP VSS m1_771_n260#
+ m1_n4711_n3022# m1_n4711_n3022# V_IP m1_771_n260# m1_771_n260# V_IP m1_n4711_n3022#
+ V_IP m1_771_n260# V_IP V_IP V_IP m1_771_n260# V_IP m1_n4711_n3022# m1_n4711_n3022#
+ m1_771_n260# m1_771_n260# V_IP V_IP m1_771_n260# V_IP m1_n4711_n3022# m1_n4711_n3022#
+ pmos
Xnmos$4_3 VSS VSS VSS VSS nmos$4
Xpmos_4 V_IN V_IN V_IN m1_771_n260# V_IN m1_771_n260# V_IN V_IN VDD m1_771_n260# V_IN
+ m1_n6873_n3119# m1_n6873_n3119# V_IN m1_n6873_n3119# V_IN V_IN VSS m1_771_n260#
+ m1_n6873_n3119# m1_n6873_n3119# V_IN m1_771_n260# m1_771_n260# V_IN m1_n6873_n3119#
+ V_IN m1_771_n260# V_IN V_IN V_IN m1_771_n260# V_IN m1_n6873_n3119# m1_n6873_n3119#
+ m1_771_n260# m1_771_n260# V_IN V_IN m1_771_n260# V_IN m1_n6873_n3119# m1_n6873_n3119#
+ pmos
Xnmos$2_0 VCMFBG VCMFBG m1_n3675_n5760# VSS m1_n3675_n5760# VSS VCMFBG m1_n3675_n5760#
+ VSS VCMFBG VSS VCMFBG nmos$2
Xpmos_5 V_IP V_IP V_IP m1_771_n260# V_IP m1_771_n260# V_IP V_IP VDD m1_771_n260# V_IP
+ m1_n4711_n3022# m1_n4711_n3022# V_IP m1_n4711_n3022# V_IP V_IP VSS m1_771_n260#
+ m1_n4711_n3022# m1_n4711_n3022# V_IP m1_771_n260# m1_771_n260# V_IP m1_n4711_n3022#
+ V_IP m1_771_n260# V_IP V_IP V_IP m1_771_n260# V_IP m1_n4711_n3022# m1_n4711_n3022#
+ m1_771_n260# m1_771_n260# V_IP V_IP m1_771_n260# V_IP m1_n4711_n3022# m1_n4711_n3022#
+ pmos
Xnmos$2_1 VCMFBG VCMFBG m1_1068_n5836# VSS m1_1068_n5836# VSS VCMFBG m1_1068_n5836#
+ VSS VCMFBG VSS VCMFBG nmos$2
Xpmos_6 V_IN V_IN V_IN m1_771_n260# V_IN m1_771_n260# V_IN V_IN VDD m1_771_n260# V_IN
+ m1_n6873_n3119# m1_n6873_n3119# V_IN m1_n6873_n3119# V_IN V_IN VSS m1_771_n260#
+ m1_n6873_n3119# m1_n6873_n3119# V_IN m1_771_n260# m1_771_n260# V_IN m1_n6873_n3119#
+ V_IN m1_771_n260# V_IN V_IN V_IN m1_771_n260# V_IN m1_n6873_n3119# m1_n6873_n3119#
+ m1_771_n260# m1_771_n260# V_IN V_IN m1_771_n260# V_IN m1_n6873_n3119# m1_n6873_n3119#
+ pmos
Xpmos_7 V_IP V_IP V_IP m1_771_n260# V_IP m1_771_n260# V_IP V_IP VDD m1_771_n260# V_IP
+ m1_n4711_n3022# m1_n4711_n3022# V_IP m1_n4711_n3022# V_IP V_IP VSS m1_771_n260#
+ m1_n4711_n3022# m1_n4711_n3022# V_IP m1_771_n260# m1_771_n260# V_IP m1_n4711_n3022#
+ V_IP m1_771_n260# V_IP V_IP V_IP m1_771_n260# V_IP m1_n4711_n3022# m1_n4711_n3022#
+ m1_771_n260# m1_771_n260# V_IP V_IP m1_771_n260# V_IP m1_n4711_n3022# m1_n4711_n3022#
+ pmos
Xnmos$2_2 VCMFBG VCMFBG m1_1068_n5836# VSS m1_1068_n5836# VSS VCMFBG m1_1068_n5836#
+ VSS VCMFBG VSS VCMFBG nmos$2
X0 VSS VSS VSS VSS sg13_lv_nmos ad=34.3068p pd=74.87u as=19.74562p ps=0.27376m w=10n l=0.5u
C0 m1_771_n260# m1_n4711_n3022# 1.63147f
C1 V_ON1 m1_n3675_n5760# 0.06606f
C2 V_ON2 V_BIAS4 0.1089f
C3 m1_n4711_n3022# m1_n6873_n3119# 2.45456f
C4 m1_771_n260# V_BIAS2 0.1837f
C5 m1_n4711_n3022# VDD 5.35623f
C6 V_ON1 m1_n4711_n3022# 0.06189f
C7 m1_n6873_n3119# V_BIAS2 2.62817f
C8 V_BIAS2 VDD 13.06703f
C9 V_ON1 V_BIAS2 1.05439f
C10 m1_n3675_n5760# m1_1068_n5836# 0.1219f
C11 V_BIAS3 V_OP1 0.49331f
C12 m1_n3675_n5760# VCMFBG 1.48449f
C13 V_OP2 V_OP1 1.60453f
C14 V_IN m1_771_n260# 2.69905f
C15 V_IN m1_n6873_n3119# 2.12938f
C16 V_IN VDD 7.61101f
C17 m1_771_n260# V_BIAS1 1.10647f
C18 V_OP1 m1_n6873_n3119# 0.04076f
C19 m1_n8092_n5681# V_ON2 0.94779f
C20 V_OP1 VDD 9.60438f
C21 VDD V_BIAS1 3.94332f
C22 V_BIAS3 m1_n6873_n3119# 0.01458f
C23 V_BIAS3 VDD 0.44712f
C24 V_IP m1_n4711_n3022# 2.61603f
C25 V_ON1 V_BIAS3 0.49732f
C26 V_OP2 VDD 2.96254f
C27 V_OP1 m1_1068_n5836# 0.06622f
C28 m1_771_n260# m1_n6873_n3119# 1.55548f
C29 V_IP V_BIAS2 0.27708f
C30 m1_771_n260# VDD 8.5718f
C31 V_OP1 m1_11721_n5608# 0.02981f
C32 V_OP2 V_BIAS4 0.10689f
C33 m1_n6873_n3119# VDD 6.30714f
C34 V_ON1 m1_n6873_n3119# 0.34435f
C35 V_ON1 VDD 9.56894f
C36 m1_n4711_n3022# V_BIAS2 2.93184f
C37 V_BIAS3 m1_1068_n5836# 0.36838f
C38 V_BIAS3 VCMFBG 0.02035f
C39 V_IP V_IN 0.68476f
C40 V_OP2 m1_11721_n5608# 1.14541f
C41 V_IP V_BIAS1 0.03121f
C42 V_IN m1_n4711_n3022# 0.69045f
C43 m1_11721_n5608# VDD 0.20752f
C44 m1_n4711_n3022# V_OP1 0.36369f
C45 V_IN V_BIAS2 0.25397f
C46 m1_n4711_n3022# V_BIAS1 0.03515f
C47 m1_11721_n5608# V_BIAS4 0.02909f
C48 V_OP1 V_BIAS2 1.03334f
C49 m1_n8092_n5681# VDD 0.18976f
C50 V_BIAS3 m1_n3675_n5760# 0.3093f
C51 V_ON1 m1_n8092_n5681# 0.02203f
C52 V_IP m1_771_n260# 2.89485f
C53 m1_n8092_n5681# V_BIAS4 0.03405f
C54 m1_1068_n5836# VCMFBG 1.13488f
C55 V_BIAS3 m1_n4711_n3022# 0.02053f
C56 V_IP m1_n6873_n3119# 0.81251f
C57 V_IP VDD 7.1055f
C58 V_ON2 VDD 2.93416f
C59 V_ON1 V_ON2 1.59831f
C60 V_BIAS3 V_BIAS2 0.13449f
C61 m1_1068_n5836# VSS 1.96289f
C62 VCMFBG VSS 2.01222f
C63 m1_n4711_n3022# VSS -0.36698f
C64 m1_771_n260# VSS -2.24407f
C65 V_IP VSS -2.73129f
C66 V_IN VSS -2.6922f
C67 m1_n6873_n3119# VSS -0.5331f
C68 V_BIAS2 VSS -2.50447f
C69 VDD VSS -4.15333f
C70 V_OP1 VSS 0.3909f
C71 m1_n3675_n5760# VSS 2.48502f
C72 V_BIAS3 VSS 3.46151f
C73 V_ON2 VSS 5.17767f
C74 V_BIAS4 VSS 5.70671f
C75 V_ON1 VSS 0.4168f
C76 V_OP2 VSS 5.14233f
C77 m1_n8092_n5681# VSS 1.72161f
C78 m1_11721_n5608# VSS 1.63077f
C79 V_BIAS1 VSS -1.4554f
.ends
